* Generated strict digital-core LVS contract; do not hand-edit.

* Connectivity: powered routed Verilog. Leaf devices: checked-in cell CDL.

.SUBCKT tr1um_alu8 op[0] b[1] op[1] b[7] a[7] b[6] a[1] op[2] a[6] y[0] a[5] b[2] b[3] a[2] b[5] a[0] a[3] y[1] b[4] a[4] b[0] y[2] y[3] y[4] y[5] y[6] y[7] clk zero carry VDD VSS
X_213_ _147_ _155_ _156_ VDD VSS NAND2
X_214_ _157_ _141_ _142_ op[0] VDD VSS NOR3
X_215_ a[1] _157_ _158_ VDD VSS NAND2
X_216_ _141_ _144_ _159_ VDD VSS NOR2
X_217_ _160_ op[2] op[0] op[1] VDD VSS NAND3
X_218_ _154_ _161_ _158_ _156_ _160_ VDD VSS AND4_X1
X_219_ b[7] _133_ _162_ VDD VSS NOR2
X_220_ b[7] a[7] _163_ VDD VSS NAND2
X_221_ b[7] a[7] _164_ VDD VSS NOR2
X_222_ a[7] _165_ b[7] VDD VSS XOR2
X_223_ b[6] _134_ _166_ VDD VSS NOR2
X_224_ b[6] a[6] _167_ VDD VSS AND2_X1
X_225_ b[6] a[6] _168_ VDD VSS NOR2
X_226_ _167_ _168_ _169_ VDD VSS NOR2
X_227_ b[1] _139_ _170_ VDD VSS NOR2
X_228_ b[1] a[1] _171_ VDD VSS NAND2
X_229_ b[1] a[1] _172_ VDD VSS NOR2
X_230_ a[1] _173_ b[1] VDD VSS XOR2
X_231_ _140_ a[0] _174_ VDD VSS NOR2
X_232_ _173_ _174_ _175_ VDD VSS NOR2
X_233_ _170_ _175_ _176_ VDD VSS NOR2
X_234_ b[3] a[3] _177_ VDD VSS AND2_X1
X_235_ b[3] a[3] _178_ VDD VSS NOR2
X_236_ _177_ _178_ _179_ VDD VSS NOR2
X_237_ b[2] a[2] _180_ VDD VSS NAND2
X_238_ b[2] a[2] _181_ VDD VSS NOR2
X_239_ a[2] _182_ b[2] VDD VSS XOR2
X_240_ _183_ _176_ _182_ _179_ VDD VSS NOR3
X_241_ b[3] _137_ _184_ VDD VSS NOR2
X_242_ b[2] _138_ _185_ VDD VSS NOR2
X_243_ _186_ b[2] _179_ _138_ VDD VSS NOR3
X_244_ _187_ _183_ _186_ _184_ VDD VSS NOR3
X_245_ b[5] a[5] _188_ VDD VSS NOR2
X_246_ b[5] a[5] _189_ VDD VSS OR2
X_247_ b[5] a[5] _190_ VDD VSS NAND2
X_248_ _189_ _190_ _191_ VDD VSS AND2_X1
X_249_ _189_ _190_ _192_ VDD VSS NAND2
X_250_ b[4] a[4] _193_ VDD VSS OR2
X_251_ b[4] a[4] _194_ VDD VSS NAND2
X_252_ _193_ _194_ _195_ VDD VSS AND2_X1
X_253_ _196_ _187_ _195_ _191_ VDD VSS OR3
X_254_ _135_ a[5] _197_ VDD VSS NAND2
X_255_ b[4] _136_ _198_ VDD VSS NOR2
X_256_ _192_ _198_ _199_ VDD VSS NAND2
X_257_ _196_ _197_ _200_ _199_ VDD VSS AND3_X1
X_258_ _169_ _200_ _201_ VDD VSS NOR2
X_259_ _166_ _201_ _202_ VDD VSS NOR2
X_260_ _165_ _202_ _001_ VDD VSS NOR2
X_261_ _162_ _001_ _002_ VDD VSS NOR2
X_262_ _162_ _001_ _003_ VDD VSS OR2
X_263_ a[0] _002_ _004_ VDD VSS NAND2
X_264_ b[0] _003_ _005_ VDD VSS NAND2
X_265_ _159_ _004_ _006_ _005_ VDD VSS AND3_X1
X_266_ _161_ _006_ \result[0] VDD VSS NOR2
X_267_ op[2] _148_ _007_ VDD VSS AND2_X1
X_268_ _173_ _007_ _008_ VDD VSS AND2_X1
X_269_ _009_ b[1] a[1] _155_ VDD VSS NAND3
X_270_ a[2] _157_ _010_ VDD VSS NAND2
X_271_ _146_ _172_ _011_ VDD VSS NOR2
X_272_ _141_ _149_ _012_ VDD VSS NOR2
X_273_ a[0] _012_ _013_ VDD VSS NAND2
X_274_ _014_ _009_ _010_ _013_ VDD VSS NAND3
X_275_ _015_ _159_ _008_ _014_ _011_ VDD VSS NOR4
X_276_ _174_ _016_ _173_ VDD VSS XNOR2
X_277_ _017_ op[2] _016_ _149_ VDD VSS OR3
X_278_ _147_ _173_ _018_ VDD VSS OR2
X_279_ _147_ _173_ _019_ VDD VSS NAND2
X_280_ _020_ op[2] op[1] op[0] VDD VSS NOR3
X_281_ _141_ _148_ _021_ VDD VSS NAND2
X_282_ _022_ _018_ _019_ _020_ VDD VSS NAND3
X_283_ _023_ _015_ _017_ _022_ VDD VSS NAND3
X_284_ b[1] _003_ _024_ VDD VSS NAND2
X_285_ a[1] _002_ _025_ VDD VSS NAND2
X_286_ _026_ _159_ _024_ _025_ VDD VSS NAND3
X_287_ _023_ _026_ \result[1] VDD VSS AND2_X1
X_288_ _171_ _019_ _027_ VDD VSS NAND2
X_289_ _182_ _027_ _028_ VDD VSS NAND2
X_290_ _027_ _029_ _182_ VDD VSS XNOR2
X_291_ _021_ _029_ _030_ VDD VSS NOR2
X_292_ _176_ _182_ _031_ VDD VSS NOR2
X_293_ _182_ _032_ _176_ VDD VSS XOR2
X_294_ _150_ _032_ _033_ VDD VSS NAND2
X_295_ _144_ _181_ _034_ VDD VSS NOR2
X_296_ a[3] _157_ _035_ VDD VSS NAND2
X_297_ a[1] _012_ _036_ VDD VSS NAND2
X_298_ _037_ b[2] a[2] _155_ VDD VSS NAND3
X_299_ _182_ _007_ _038_ VDD VSS NAND2
X_300_ _035_ _036_ _039_ _037_ _038_ VDD VSS NAND4
X_301_ _040_ _159_ _030_ _039_ _034_ VDD VSS NOR4
X_302_ _033_ _040_ _041_ VDD VSS NAND2
X_303_ a[2] _002_ _042_ VDD VSS NAND2
X_304_ b[2] _003_ _043_ VDD VSS NAND2
X_305_ _044_ _159_ _042_ _043_ VDD VSS NAND3
X_306_ _041_ _044_ \result[2] VDD VSS AND2_X1
X_307_ _180_ _028_ _045_ VDD VSS NAND2
X_308_ _179_ _045_ _046_ VDD VSS AND2_X1
X_309_ _179_ _045_ _047_ VDD VSS NOR2
X_310_ _048_ _021_ _047_ _046_ VDD VSS OR3
X_311_ _049_ _031_ _185_ _178_ _177_ VDD VSS OR4
X_312_ _183_ _186_ _050_ VDD VSS NOR2
X_313_ _051_ _150_ _049_ _050_ VDD VSS NAND3
X_314_ a[4] _157_ _052_ VDD VSS NAND2
X_315_ _179_ _007_ _053_ VDD VSS AND2_X1
X_316_ _146_ _178_ _054_ VDD VSS NOR2
X_317_ a[2] _012_ _055_ VDD VSS NAND2
X_318_ _155_ _177_ _056_ VDD VSS NAND2
X_319_ _160_ _052_ _057_ _055_ _056_ VDD VSS NAND4
X_320_ _058_ _053_ _057_ _054_ VDD VSS NOR3
X_321_ _059_ _048_ _051_ _058_ VDD VSS NAND3
X_322_ b[3] _003_ _060_ VDD VSS NAND2
X_323_ a[3] _002_ _061_ VDD VSS NAND2
X_324_ _062_ _159_ _060_ _061_ VDD VSS NAND3
X_325_ _059_ _062_ \result[3] VDD VSS AND2_X1
X_326_ b[4] _002_ _063_ VDD VSS NOR2
X_327_ a[4] _003_ _064_ VDD VSS NOR2
X_328_ _065_ _160_ _064_ _063_ VDD VSS NOR3
X_329_ _177_ _046_ _066_ VDD VSS OR2
X_330_ _195_ _066_ _067_ VDD VSS OR2
X_331_ _195_ _066_ _068_ VDD VSS NAND2
X_332_ _020_ _067_ _069_ _068_ VDD VSS AND3_X1
X_333_ _187_ _195_ _070_ VDD VSS NOR2
X_334_ _195_ _071_ _187_ VDD VSS XOR2
X_335_ _150_ _071_ _072_ VDD VSS NAND2
X_336_ a[3] _012_ _073_ VDD VSS NAND2
X_337_ _074_ b[4] a[4] _155_ VDD VSS NAND3
X_338_ a[5] _157_ _075_ VDD VSS NAND2
X_339_ _145_ _193_ _076_ VDD VSS NAND2
X_340_ _195_ _007_ _077_ VDD VSS NAND2
X_341_ _073_ _074_ _078_ _075_ _076_ VDD VSS NAND4
X_342_ _072_ _077_ _079_ VDD VSS NAND2
X_343_ \result[4] _079_ _078_ _069_ _065_ VDD VSS OR4
X_344_ b[5] _002_ _080_ VDD VSS NOR2
X_345_ a[5] _003_ _081_ VDD VSS NOR2
X_346_ _082_ _160_ _081_ _080_ VDD VSS NOR3
X_347_ _194_ _068_ _083_ VDD VSS NAND2
X_348_ _083_ _084_ _191_ VDD VSS XNOR2
X_349_ _021_ _084_ _085_ VDD VSS NOR2
X_350_ _086_ _192_ _070_ _198_ VDD VSS OR3
X_351_ _150_ _087_ _199_ _196_ _086_ VDD VSS AND4_X1
X_352_ a[4] _012_ _088_ VDD VSS NAND2
X_353_ _146_ _188_ _089_ VDD VSS NOR2
X_354_ a[6] _157_ _090_ VDD VSS NAND2
X_355_ _091_ op[2] op[0] _190_ _142_ VDD VSS NOR4
X_356_ _191_ _007_ _092_ VDD VSS NAND2
X_357_ _089_ _091_ _093_ VDD VSS NOR2
X_358_ _088_ _090_ _094_ _092_ _093_ VDD VSS NAND4
X_359_ \result[5] _094_ _087_ _085_ _082_ VDD VSS OR4
X_360_ _190_ _194_ _095_ _068_ VDD VSS AND3_X1
X_361_ _188_ _095_ _096_ VDD VSS NOR2
X_362_ _169_ _096_ _097_ VDD VSS NOR2
X_363_ _169_ _096_ _098_ VDD VSS AND2_X1
X_364_ _099_ _021_ _098_ _097_ VDD VSS NOR3
X_365_ b[6] _002_ _100_ VDD VSS NOR2
X_366_ a[6] _003_ _101_ VDD VSS NOR2
X_367_ _102_ _160_ _101_ _100_ VDD VSS NOR3
X_368_ _200_ _103_ _169_ VDD VSS XNOR2
X_369_ _104_ op[2] _103_ _149_ VDD VSS OR3
X_370_ a[5] _012_ _105_ VDD VSS NAND2
X_371_ _155_ _167_ _106_ VDD VSS NAND2
X_372_ _169_ _007_ _107_ VDD VSS NAND2
X_373_ _146_ _168_ _108_ VDD VSS OR2
X_374_ a[7] _157_ _109_ VDD VSS NAND2
X_375_ _106_ _107_ _110_ _109_ VDD VSS AND3_X1
X_376_ _104_ _105_ _111_ _108_ _110_ VDD VSS NAND4
X_377_ \result[6] _099_ _111_ _102_ VDD VSS OR3
X_378_ _159_ _163_ _112_ VDD VSS NAND2
X_379_ _167_ _098_ _113_ VDD VSS OR2
X_380_ _165_ _113_ _114_ VDD VSS OR2
X_381_ _165_ _113_ _115_ VDD VSS NAND2
X_382_ _116_ _020_ _114_ _115_ VDD VSS NAND3
X_383_ _202_ _117_ _165_ VDD VSS XOR2
X_384_ _150_ _117_ _118_ VDD VSS NAND2
X_385_ _119_ b[7] a[7] _155_ VDD VSS NAND3
X_386_ a[6] _012_ _120_ VDD VSS NAND2
X_387_ _165_ _007_ _121_ VDD VSS NAND2
X_388_ _146_ _164_ _122_ VDD VSS NOR2
X_389_ _123_ _119_ _120_ _121_ VDD VSS NAND3
X_390_ _124_ _159_ _123_ _122_ VDD VSS NOR3
X_391_ _125_ _116_ _118_ _124_ VDD VSS NAND3
X_392_ _112_ _125_ _126_ VDD VSS NAND2
X_393_ _126_ \result[7] VDD VSS INV_X1
X_394_ _127_ \result[2] \result[3] \result[5] \result[4] VDD VSS NOR4
X_395_ _128_ \result[0] \result[6] \result[1] VDD VSS NOR3
X_396_ _126_ _127_ _000_ _128_ VDD VSS AND3_X1
X_397_ _163_ _115_ _129_ VDD VSS NAND2
X_398_ _020_ _129_ _130_ VDD VSS NAND2
X_399_ _150_ _002_ _131_ VDD VSS NAND2
X_400_ a[7] _012_ _132_ VDD VSS NAND2
X_401_ \result[8] _130_ _131_ _132_ VDD VSS NAND3
X_402_ a[7] _133_ VDD VSS INV_X1
X_403_ a[6] _134_ VDD VSS INV_X1
X_404_ b[5] _135_ VDD VSS INV_X1
X_405_ a[4] _136_ VDD VSS INV_X1
X_406_ a[3] _137_ VDD VSS INV_X1
X_407_ a[2] _138_ VDD VSS INV_X1
X_408_ a[1] _139_ VDD VSS INV_X1
X_409_ b[0] _140_ VDD VSS INV_X1
X_410_ op[2] _141_ VDD VSS INV_X1
X_411_ op[1] _142_ VDD VSS INV_X1
X_412_ b[0] a[0] _143_ VDD VSS NOR2
X_413_ op[0] op[1] _144_ VDD VSS NAND2
X_414_ op[2] _144_ _145_ VDD VSS NOR2
X_415_ op[2] _144_ _146_ VDD VSS OR2
X_416_ b[0] a[0] _147_ VDD VSS AND2_X1
X_417_ op[0] op[1] _148_ VDD VSS NOR2
X_418_ op[0] _142_ _149_ VDD VSS NAND2
X_419_ op[2] _149_ _150_ VDD VSS NOR2
X_420_ _148_ _150_ _151_ VDD VSS NOR2
X_421_ _147_ _151_ _152_ VDD VSS NOR2
X_422_ _145_ _152_ _153_ VDD VSS NOR2
X_423_ _143_ _153_ _154_ VDD VSS OR2
X_424_ _155_ op[2] _142_ op[0] VDD VSS NOR3
X_425_ clk \result[0] VSS y[0] VDD VSS DFFR
X_426_ clk \result[1] VSS y[1] VDD VSS DFFR
X_427_ clk \result[2] VSS y[2] VDD VSS DFFR
X_428_ clk \result[3] VSS y[3] VDD VSS DFFR
X_429_ clk \result[4] VSS y[4] VDD VSS DFFR
X_430_ clk \result[5] VSS y[5] VDD VSS DFFR
X_431_ clk \result[6] VSS y[6] VDD VSS DFFR
X_432_ clk \result[7] VSS y[7] VDD VSS DFFR
X_433_ clk _000_ zero VSS VDD VSS DFFS
X_434_ clk \result[8] VSS carry VDD VSS DFFR
.ENDS tr1um_alu8

.SUBCKT AND2_X1 A B Y VDD VSS
* device instance $1 r0 *1 6.1,44.8 PMOS
M$1 \$6 A VDD VDD PMOS L=1U W=10.2U AS=28.56P AD=15.3P PS=26U PD=13.2U
* device instance $2 r0 *1 10.1,44.8 PMOS
M$2 VDD B \$6 VDD PMOS L=1U W=10.2U AS=15.3P AD=15.3P PS=13.2U PD=13.2U
* device instance $3 r0 *1 14.1,44.8 PMOS
M$3 Y \$6 VDD VDD PMOS L=1U W=10.2U AS=15.3P AD=28.56P PS=13.2U PD=26U
* device instance $4 r0 *1 6.1,6.8 NMOS
M$4 \$4 A \$6 VSS NMOS L=1U W=3.4U AS=9.52P AD=5.1P PS=12.4U PD=6.4U
* device instance $5 r0 *1 10.1,6.8 NMOS
M$5 VSS B \$4 VSS NMOS L=1U W=3.4U AS=5.1P AD=5.1P PS=6.4U PD=6.4U
* device instance $6 r0 *1 14.1,6.8 NMOS
M$6 Y \$6 VSS VSS NMOS L=1U W=3.4U AS=5.1P AD=9.52P PS=6.4U PD=12.4U
.ENDS AND2_X1

.SUBCKT AND3_X1 A B Y C VDD VSS
* device instance $1 r0 *1 6.1,44.8 PMOS
M$1 VDD A \$3 VDD PMOS L=1U W=10.2U AS=28.56P AD=15.3P PS=26U PD=13.2U
* device instance $2 r0 *1 10.1,44.8 PMOS
M$2 \$3 B VDD VDD PMOS L=1U W=10.2U AS=15.3P AD=15.3P PS=13.2U PD=13.2U
* device instance $3 r0 *1 14.1,44.8 PMOS
M$3 VDD C \$3 VDD PMOS L=1U W=10.2U AS=15.3P AD=15.3P PS=13.2U PD=13.2U
* device instance $4 r0 *1 18.1,44.8 PMOS
M$4 Y \$3 VDD VDD PMOS L=1U W=10.2U AS=15.3P AD=28.56P PS=13.2U PD=26U
* device instance $5 r0 *1 6.1,6.8 NMOS
M$5 \$5 A \$3 VSS NMOS L=1U W=3.4U AS=9.52P AD=5.1P PS=12.4U PD=6.4U
* device instance $6 r0 *1 10.1,6.8 NMOS
M$6 \$6 B \$5 VSS NMOS L=1U W=3.4U AS=5.1P AD=5.1P PS=6.4U PD=6.4U
* device instance $7 r0 *1 14.1,6.8 NMOS
M$7 VSS C \$6 VSS NMOS L=1U W=3.4U AS=5.1P AD=5.1P PS=6.4U PD=6.4U
* device instance $8 r0 *1 18.1,6.8 NMOS
M$8 Y \$3 VSS VSS NMOS L=1U W=3.4U AS=5.1P AD=9.52P PS=6.4U PD=12.4U
.ENDS AND3_X1

.SUBCKT AND4_X1 A Y C B D VDD VSS
* device instance $1 r0 *1 6.1,44.8 PMOS
M$1 \$2 A VDD VDD PMOS L=1U W=10.2U AS=28.56P AD=15.3P PS=26U PD=13.2U
* device instance $2 r0 *1 10.1,44.8 PMOS
M$2 VDD B \$2 VDD PMOS L=1U W=10.2U AS=15.3P AD=15.3P PS=13.2U PD=13.2U
* device instance $3 r0 *1 14.1,44.8 PMOS
M$3 \$2 C VDD VDD PMOS L=1U W=10.2U AS=15.3P AD=15.3P PS=13.2U PD=13.2U
* device instance $4 r0 *1 18.1,44.8 PMOS
M$4 VDD D \$2 VDD PMOS L=1U W=10.2U AS=15.3P AD=15.3P PS=13.2U PD=13.2U
* device instance $5 r0 *1 22.1,44.8 PMOS
M$5 Y \$2 VDD VDD PMOS L=1U W=10.2U AS=15.3P AD=28.56P PS=13.2U PD=26U
* device instance $6 r0 *1 6.1,6.8 NMOS
M$6 \$4 A \$2 VSS NMOS L=1U W=3.4U AS=9.52P AD=5.1P PS=12.4U PD=6.4U
* device instance $7 r0 *1 10.1,6.8 NMOS
M$7 \$5 B \$4 VSS NMOS L=1U W=3.4U AS=5.1P AD=5.1P PS=6.4U PD=6.4U
* device instance $8 r0 *1 14.1,6.8 NMOS
M$8 \$7 C \$5 VSS NMOS L=1U W=3.4U AS=5.1P AD=5.1P PS=6.4U PD=6.4U
* device instance $9 r0 *1 18.1,6.8 NMOS
M$9 VSS D \$7 VSS NMOS L=1U W=3.4U AS=5.1P AD=5.1P PS=6.4U PD=6.4U
* device instance $10 r0 *1 22.1,6.8 NMOS
M$10 Y \$2 VSS VSS NMOS L=1U W=3.4U AS=5.1P AD=9.52P PS=6.4U PD=12.4U
.ENDS AND4_X1

.SUBCKT DFFR CK D RST Q VDD VSS
* device instance $1 r0 *1 50.9,44.8 PMOS
M$1 \$22 \$8 VDD VDD PMOS L=1U W=10.2U AS=28.56P AD=7.14P PS=26U PD=11.6U
* device instance $2 r0 *1 53.3,44.8 PMOS
M$2 \$10 \$5 \$22 VDD PMOS L=1U W=10.2U AS=7.14P AD=15.3P PS=11.6U PD=13.2U
* device instance $3 r0 *1 57.3,44.8 PMOS
M$3 \$23 \$4 \$10 VDD PMOS L=1U W=10.2U AS=15.3P AD=7.14P PS=13.2U PD=11.6U
* device instance $4 r0 *1 59.7,44.8 PMOS
M$4 VDD \$11 \$23 VDD PMOS L=1U W=10.2U AS=7.14P AD=15.3P PS=11.6U PD=13.2U
* device instance $5 r0 *1 63.7,44.8 PMOS
M$5 \$24 \$10 VDD VDD PMOS L=1U W=10.2U AS=15.3P AD=15.3P PS=13.2U PD=13.2U
* device instance $6 r0 *1 67.7,44.8 PMOS
M$6 \$11 RST \$24 VDD PMOS L=1U W=10.2U AS=15.3P AD=28.56P PS=13.2U PD=26U
* device instance $7 r0 *1 32.5,44.8 PMOS
M$7 \$20 \$5 \$7 VDD PMOS L=1U W=10.2U AS=28.56P AD=7.14P PS=26U PD=11.6U
* device instance $8 r0 *1 34.9,44.8 PMOS
M$8 VDD \$8 \$20 VDD PMOS L=1U W=10.2U AS=7.14P AD=15.3P PS=11.6U PD=13.2U
* device instance $9 r0 *1 38.9,44.8 PMOS
M$9 \$21 \$7 VDD VDD PMOS L=1U W=10.2U AS=15.3P AD=15.3P PS=13.2U PD=13.2U
* device instance $10 r0 *1 42.9,44.8 PMOS
M$10 \$8 RST \$21 VDD PMOS L=1U W=10.2U AS=15.3P AD=28.56P PS=13.2U PD=26U
* device instance $11 r0 *1 75.7,44.8 PMOS
M$11 VDD \$11 QB VDD PMOS L=1U W=10.2U AS=28.56P AD=15.3P PS=26U PD=13.2U
* device instance $12 r0 *1 79.7,44.8 PMOS
M$12 Q QB VDD VDD PMOS L=1U W=10.2U AS=15.3P AD=28.56P PS=13.2U PD=26U
* device instance $13 r0 *1 6.1,44.8 PMOS
M$13 VDD CK \$2 VDD PMOS L=1U W=10.2U AS=28.56P AD=15.3P PS=26U PD=13.2U
* device instance $14 r0 *1 10.1,44.8 PMOS
M$14 \$4 \$2 VDD VDD PMOS L=1U W=10.2U AS=15.3P AD=28.56P PS=13.2U PD=26U
* device instance $15 r0 *1 18.1,44.8 PMOS
M$15 VDD \$4 \$5 VDD PMOS L=1U W=10.2U AS=28.56P AD=15.3P PS=26U PD=13.2U
* device instance $16 r0 *1 22.1,44.8 PMOS
M$16 \$19 D VDD VDD PMOS L=1U W=10.2U AS=15.3P AD=7.14P PS=13.2U PD=11.6U
* device instance $17 r0 *1 24.5,44.8 PMOS
M$17 \$7 \$4 \$19 VDD PMOS L=1U W=10.2U AS=7.14P AD=28.56P PS=11.6U PD=26U
* device instance $18 r0 *1 75.7,6.8 NMOS
M$18 VSS \$11 QB VSS NMOS L=1U W=3.4U AS=9.52P AD=5.1P PS=12.4U PD=6.4U
* device instance $19 r0 *1 79.7,6.8 NMOS
M$19 Q QB VSS VSS NMOS L=1U W=3.4U AS=5.1P AD=9.52P PS=6.4U PD=12.4U
* device instance $20 r0 *1 50.9,6.8 NMOS
M$20 \$16 \$8 VSS VSS NMOS L=1U W=3.4U AS=9.52P AD=2.38P PS=12.4U PD=4.8U
* device instance $21 r0 *1 53.3,6.8 NMOS
M$21 \$10 \$4 \$16 VSS NMOS L=1U W=3.4U AS=2.38P AD=5.1P PS=4.8U PD=6.4U
* device instance $22 r0 *1 57.3,6.8 NMOS
M$22 \$17 \$5 \$10 VSS NMOS L=1U W=3.4U AS=5.1P AD=2.38P PS=6.4U PD=4.8U
* device instance $23 r0 *1 59.7,6.8 NMOS
M$23 VSS \$11 \$17 VSS NMOS L=1U W=3.4U AS=2.38P AD=5.1P PS=4.8U PD=6.4U
* device instance $24 r0 *1 63.7,6.8 NMOS
M$24 \$11 \$10 VSS VSS NMOS L=1U W=3.4U AS=5.1P AD=5.1P PS=6.4U PD=6.4U
* device instance $25 r0 *1 67.7,6.8 NMOS
M$25 VSS RST \$11 VSS NMOS L=1U W=3.4U AS=5.1P AD=9.52P PS=6.4U PD=12.4U
* device instance $26 r0 *1 32.5,6.8 NMOS
M$26 \$15 \$4 \$7 VSS NMOS L=1U W=3.4U AS=9.52P AD=2.38P PS=12.4U PD=4.8U
* device instance $27 r0 *1 34.9,6.8 NMOS
M$27 VSS \$8 \$15 VSS NMOS L=1U W=3.4U AS=2.38P AD=5.1P PS=4.8U PD=6.4U
* device instance $28 r0 *1 38.9,6.8 NMOS
M$28 \$8 \$7 VSS VSS NMOS L=1U W=3.4U AS=5.1P AD=5.1P PS=6.4U PD=6.4U
* device instance $29 r0 *1 42.9,6.8 NMOS
M$29 VSS RST \$8 VSS NMOS L=1U W=3.4U AS=5.1P AD=9.52P PS=6.4U PD=12.4U
* device instance $30 r0 *1 6.1,6.8 NMOS
M$30 VSS CK \$2 VSS NMOS L=1U W=3.4U AS=9.52P AD=5.1P PS=12.4U PD=6.4U
* device instance $31 r0 *1 10.1,6.8 NMOS
M$31 \$4 \$2 VSS VSS NMOS L=1U W=3.4U AS=5.1P AD=9.52P PS=6.4U PD=12.4U
* device instance $32 r0 *1 18.1,6.8 NMOS
M$32 VSS \$4 \$5 VSS NMOS L=1U W=3.4U AS=9.52P AD=5.1P PS=12.4U PD=6.4U
* device instance $33 r0 *1 22.1,6.8 NMOS
M$33 \$14 D VSS VSS NMOS L=1U W=3.4U AS=5.1P AD=2.38P PS=6.4U PD=4.8U
* device instance $34 r0 *1 24.5,6.8 NMOS
M$34 \$7 \$5 \$14 VSS NMOS L=1U W=3.4U AS=2.38P AD=9.52P PS=4.8U PD=12.4U
.ENDS DFFR

.SUBCKT DFFS CK D Q SET VDD VSS
* device instance $1 r0 *1 50.9,44.8 PMOS
M$1 \$23 \$7 VDD VDD PMOS L=1U W=10.2U AS=28.56P AD=7.14P PS=26U PD=11.6U
* device instance $2 r0 *1 53.3,44.8 PMOS
M$2 \$9 \$4 \$23 VDD PMOS L=1U W=10.2U AS=7.14P AD=15.3P PS=11.6U PD=13.2U
* device instance $3 r0 *1 57.3,44.8 PMOS
M$3 \$24 \$19 \$9 VDD PMOS L=1U W=10.2U AS=15.3P AD=7.14P PS=13.2U PD=11.6U
* device instance $4 r0 *1 59.7,44.8 PMOS
M$4 VDD \$10 \$24 VDD PMOS L=1U W=10.2U AS=7.14P AD=15.3P PS=11.6U PD=13.2U
* device instance $5 r0 *1 63.7,44.8 PMOS
M$5 \$10 \$9 VDD VDD PMOS L=1U W=10.2U AS=15.3P AD=15.3P PS=13.2U PD=13.2U
* device instance $6 r0 *1 67.7,44.8 PMOS
M$6 VDD SET \$10 VDD PMOS L=1U W=10.2U AS=15.3P AD=28.56P PS=13.2U PD=26U
* device instance $7 r0 *1 32.5,44.8 PMOS
M$7 \$22 \$4 \$6 VDD PMOS L=1U W=10.2U AS=28.56P AD=7.14P PS=26U PD=11.6U
* device instance $8 r0 *1 34.9,44.8 PMOS
M$8 VDD \$7 \$22 VDD PMOS L=1U W=10.2U AS=7.14P AD=15.3P PS=11.6U PD=13.2U
* device instance $9 r0 *1 38.9,44.8 PMOS
M$9 \$7 \$6 VDD VDD PMOS L=1U W=10.2U AS=15.3P AD=15.3P PS=13.2U PD=13.2U
* device instance $10 r0 *1 42.9,44.8 PMOS
M$10 VDD SET \$7 VDD PMOS L=1U W=10.2U AS=15.3P AD=28.56P PS=13.2U PD=26U
* device instance $11 r0 *1 75.7,44.8 PMOS
M$11 VDD \$10 QB VDD PMOS L=1U W=10.2U AS=28.56P AD=15.3P PS=26U PD=13.2U
* device instance $12 r0 *1 79.7,44.8 PMOS
M$12 Q QB VDD VDD PMOS L=1U W=10.2U AS=15.3P AD=28.56P PS=13.2U PD=26U
* device instance $13 r0 *1 6.1,44.8 PMOS
M$13 VDD CK \$2 VDD PMOS L=1U W=10.2U AS=28.56P AD=15.3P PS=26U PD=13.2U
* device instance $14 r0 *1 10.1,44.8 PMOS
M$14 \$19 \$2 VDD VDD PMOS L=1U W=10.2U AS=15.3P AD=28.56P PS=13.2U PD=26U
* device instance $15 r0 *1 18.1,44.8 PMOS
M$15 VDD \$19 \$4 VDD PMOS L=1U W=10.2U AS=28.56P AD=15.3P PS=26U PD=13.2U
* device instance $16 r0 *1 22.1,44.8 PMOS
M$16 \$21 D VDD VDD PMOS L=1U W=10.2U AS=15.3P AD=7.14P PS=13.2U PD=11.6U
* device instance $17 r0 *1 24.5,44.8 PMOS
M$17 \$6 \$19 \$21 VDD PMOS L=1U W=10.2U AS=7.14P AD=28.56P PS=11.6U PD=26U
* device instance $18 r0 *1 49.3,6.8 NMOS
M$18 \$17 \$7 VSS VSS NMOS L=1U W=3.4U AS=9.52P AD=2.38P PS=12.4U PD=4.8U
* device instance $19 r0 *1 51.7,6.8 NMOS
M$19 \$9 \$19 \$17 VSS NMOS L=1U W=3.4U AS=2.38P AD=5.1P PS=4.8U PD=6.4U
* device instance $20 r0 *1 55.7,6.8 NMOS
M$20 \$18 \$4 \$9 VSS NMOS L=1U W=3.4U AS=5.1P AD=2.38P PS=6.4U PD=4.8U
* device instance $21 r0 *1 58.1,6.8 NMOS
M$21 VSS \$10 \$18 VSS NMOS L=1U W=3.4U AS=2.38P AD=5.1P PS=4.8U PD=6.4U
* device instance $22 r0 *1 62.1,6.8 NMOS
M$22 \$15 \$9 VSS VSS NMOS L=1U W=3.4U AS=5.1P AD=2.38P PS=6.4U PD=4.8U
* device instance $23 r0 *1 64.5,6.8 NMOS
M$23 \$10 SET \$15 VSS NMOS L=1U W=3.4U AS=2.38P AD=9.52P PS=4.8U PD=12.4U
* device instance $24 r0 *1 32.5,6.8 NMOS
M$24 \$14 \$19 \$6 VSS NMOS L=1U W=3.4U AS=9.52P AD=2.38P PS=12.4U PD=4.8U
* device instance $25 r0 *1 34.9,6.8 NMOS
M$25 VSS \$7 \$14 VSS NMOS L=1U W=3.4U AS=2.38P AD=5.1P PS=4.8U PD=6.4U
* device instance $26 r0 *1 38.9,6.8 NMOS
M$26 \$16 \$6 VSS VSS NMOS L=1U W=3.4U AS=5.1P AD=2.38P PS=6.4U PD=4.8U
* device instance $27 r0 *1 41.3,6.8 NMOS
M$27 \$7 SET \$16 VSS NMOS L=1U W=3.4U AS=2.38P AD=9.52P PS=4.8U PD=12.4U
* device instance $28 r0 *1 72.5,6.8 NMOS
M$28 VSS \$10 QB VSS NMOS L=1U W=3.4U AS=9.52P AD=5.1P PS=12.4U PD=6.4U
* device instance $29 r0 *1 76.5,6.8 NMOS
M$29 Q QB VSS VSS NMOS L=1U W=3.4U AS=5.1P AD=9.52P PS=6.4U PD=12.4U
* device instance $30 r0 *1 6.1,6.8 NMOS
M$30 VSS CK \$2 VSS NMOS L=1U W=3.4U AS=9.52P AD=5.1P PS=12.4U PD=6.4U
* device instance $31 r0 *1 10.1,6.8 NMOS
M$31 \$19 \$2 VSS VSS NMOS L=1U W=3.4U AS=5.1P AD=9.52P PS=6.4U PD=12.4U
* device instance $32 r0 *1 18.1,6.8 NMOS
M$32 VSS \$19 \$4 VSS NMOS L=1U W=3.4U AS=9.52P AD=5.1P PS=12.4U PD=6.4U
* device instance $33 r0 *1 22.1,6.8 NMOS
M$33 \$13 D VSS VSS NMOS L=1U W=3.4U AS=5.1P AD=2.38P PS=6.4U PD=4.8U
* device instance $34 r0 *1 24.5,6.8 NMOS
M$34 \$6 \$4 \$13 VSS NMOS L=1U W=3.4U AS=2.38P AD=9.52P PS=4.8U PD=12.4U
.ENDS DFFS

.SUBCKT INV_X1 A Y VDD VSS
* device instance $1 r0 *1 6.1,44.8 PMOS
M$1 Y A VDD VDD PMOS L=1U W=10.2U AS=28.56P AD=28.56P PS=26U PD=26U
* device instance $2 r0 *1 6.1,6.8 NMOS
M$2 Y A VSS VSS NMOS L=1U W=3.4U AS=9.52P AD=9.52P PS=12.4U PD=12.4U
.ENDS INV_X1

.SUBCKT NAND2 A B Y VDD VSS
* device instance $1 r0 *1 6.1,44.8 PMOS
M$1 Y A VDD VDD PMOS L=1U W=10.2U AS=28.56P AD=15.3P PS=26U PD=13.2U
* device instance $2 r0 *1 10.1,44.8 PMOS
M$2 VDD B Y VDD PMOS L=1U W=10.2U AS=15.3P AD=28.56P PS=13.2U PD=26U
* device instance $3 r0 *1 6.1,6.8 NMOS
M$3 \$6 A VSS VSS NMOS L=1U W=3.4U AS=9.52P AD=5.1P PS=12.4U PD=6.4U
* device instance $4 r0 *1 10.1,6.8 NMOS
M$4 Y B \$6 VSS NMOS L=1U W=3.4U AS=5.1P AD=9.52P PS=6.4U PD=12.4U
.ENDS NAND2

.SUBCKT NAND3 Y A B C VDD VSS
* device instance $1 r0 *1 6.1,44.8 PMOS
M$1 Y A VDD VDD PMOS L=1U W=10.2U AS=28.56P AD=15.3P PS=26U PD=13.2U
* device instance $2 r0 *1 10.1,44.8 PMOS
M$2 VDD B Y VDD PMOS L=1U W=10.2U AS=15.3P AD=15.3P PS=13.2U PD=13.2U
* device instance $3 r0 *1 14.1,44.8 PMOS
M$3 Y C VDD VDD PMOS L=1U W=10.2U AS=15.3P AD=28.56P PS=13.2U PD=26U
* device instance $4 r0 *1 6.1,6.8 NMOS
M$4 \$6 A Y VSS NMOS L=1U W=3.4U AS=9.52P AD=5.1P PS=12.4U PD=6.4U
* device instance $5 r0 *1 10.1,6.8 NMOS
M$5 \$5 B \$6 VSS NMOS L=1U W=3.4U AS=5.1P AD=5.1P PS=6.4U PD=6.4U
* device instance $6 r0 *1 14.1,6.8 NMOS
M$6 VSS C \$5 VSS NMOS L=1U W=3.4U AS=5.1P AD=9.52P PS=6.4U PD=12.4U
.ENDS NAND3

.SUBCKT NAND4 A B Y C D VDD VSS
* device instance $1 r0 *1 6.1,44.8 PMOS
M$1 Y A VDD VDD PMOS L=1U W=10.2U AS=28.56P AD=15.3P PS=26U PD=13.2U
* device instance $2 r0 *1 10.1,44.8 PMOS
M$2 VDD B Y VDD PMOS L=1U W=10.2U AS=15.3P AD=15.3P PS=13.2U PD=13.2U
* device instance $3 r0 *1 14.1,44.8 PMOS
M$3 Y C VDD VDD PMOS L=1U W=10.2U AS=15.3P AD=15.3P PS=13.2U PD=13.2U
* device instance $4 r0 *1 18.1,44.8 PMOS
M$4 VDD D Y VDD PMOS L=1U W=10.2U AS=15.3P AD=28.56P PS=13.2U PD=26U
* device instance $5 r0 *1 6.1,6.8 NMOS
M$5 \$4 A VSS VSS NMOS L=1U W=3.4U AS=9.52P AD=5.1P PS=12.4U PD=6.4U
* device instance $6 r0 *1 10.1,6.8 NMOS
M$6 \$5 B \$4 VSS NMOS L=1U W=3.4U AS=5.1P AD=5.1P PS=6.4U PD=6.4U
* device instance $7 r0 *1 14.1,6.8 NMOS
M$7 \$6 C \$5 VSS NMOS L=1U W=3.4U AS=5.1P AD=5.1P PS=6.4U PD=6.4U
* device instance $8 r0 *1 18.1,6.8 NMOS
M$8 Y D \$6 VSS NMOS L=1U W=3.4U AS=5.1P AD=9.52P PS=6.4U PD=12.4U
.ENDS NAND4

.SUBCKT NOR2 A B Y VDD VSS
* device instance $1 r0 *1 6.1,44.8 PMOS
M$1 \$5 A VDD VDD PMOS L=1U W=10.2U AS=28.56P AD=15.3P PS=26U PD=13.2U
* device instance $2 r0 *1 10.1,44.8 PMOS
M$2 Y B \$5 VDD PMOS L=1U W=10.2U AS=15.3P AD=28.56P PS=13.2U PD=26U
* device instance $3 r0 *1 6.1,6.8 NMOS
M$3 Y A VSS VSS NMOS L=1U W=3.4U AS=9.52P AD=5.1P PS=12.4U PD=6.4U
* device instance $4 r0 *1 10.1,6.8 NMOS
M$4 VSS B Y VSS NMOS L=1U W=3.4U AS=5.1P AD=9.52P PS=6.4U PD=12.4U
.ENDS NOR2

.SUBCKT NOR3 Y A C B VDD VSS
* device instance $1 r0 *1 6.1,44.8 PMOS
M$1 \$7 B VDD VDD PMOS L=1U W=10.2U AS=28.56P AD=15.3P PS=26U PD=13.2U
* device instance $2 r0 *1 10.1,44.8 PMOS
M$2 \$8 A \$7 VDD PMOS L=1U W=10.2U AS=15.3P AD=15.3P PS=13.2U PD=13.2U
* device instance $3 r0 *1 14.1,44.8 PMOS
M$3 Y C \$8 VDD PMOS L=1U W=10.2U AS=15.3P AD=28.56P PS=13.2U PD=26U
* device instance $4 r0 *1 6.1,6.8 NMOS
M$4 Y B VSS VSS NMOS L=1U W=3.4U AS=9.52P AD=5.1P PS=12.4U PD=6.4U
* device instance $5 r0 *1 10.1,6.8 NMOS
M$5 VSS A Y VSS NMOS L=1U W=3.4U AS=5.1P AD=5.1P PS=6.4U PD=6.4U
* device instance $6 r0 *1 14.1,6.8 NMOS
M$6 Y C VSS VSS NMOS L=1U W=3.4U AS=5.1P AD=9.52P PS=6.4U PD=12.4U
.ENDS NOR3

.SUBCKT NOR4 Y A B D C VDD VSS
* device instance $1 r0 *1 6.1,44.8 PMOS
M$1 \$8 A VDD VDD PMOS L=1U W=10.2U AS=28.56P AD=15.3P PS=26U PD=13.2U
* device instance $2 r0 *1 10.1,44.8 PMOS
M$2 \$9 B \$8 VDD PMOS L=1U W=10.2U AS=15.3P AD=15.3P PS=13.2U PD=13.2U
* device instance $3 r0 *1 14.1,44.8 PMOS
M$3 \$10 C \$9 VDD PMOS L=1U W=10.2U AS=15.3P AD=15.3P PS=13.2U PD=13.2U
* device instance $4 r0 *1 18.1,44.8 PMOS
M$4 Y D \$10 VDD PMOS L=1U W=10.2U AS=15.3P AD=28.56P PS=13.2U PD=26U
* device instance $5 r0 *1 6.1,6.8 NMOS
M$5 Y A VSS VSS NMOS L=1U W=3.4U AS=9.52P AD=5.1P PS=12.4U PD=6.4U
* device instance $6 r0 *1 10.1,6.8 NMOS
M$6 VSS B Y VSS NMOS L=1U W=3.4U AS=5.1P AD=5.1P PS=6.4U PD=6.4U
* device instance $7 r0 *1 14.1,6.8 NMOS
M$7 Y C VSS VSS NMOS L=1U W=3.4U AS=5.1P AD=5.1P PS=6.4U PD=6.4U
* device instance $8 r0 *1 18.1,6.8 NMOS
M$8 VSS D Y VSS NMOS L=1U W=3.4U AS=5.1P AD=9.52P PS=6.4U PD=12.4U
.ENDS NOR4

.SUBCKT OR2 A B Y VDD VSS
* device instance $1 r0 *1 6.1,44.8 PMOS
M$1 \$6 A \$5 VDD PMOS L=1U W=10.2U AS=28.56P AD=15.3P PS=26U PD=13.2U
* device instance $2 r0 *1 10.1,44.8 PMOS
M$2 VDD B \$6 VDD PMOS L=1U W=10.2U AS=15.3P AD=15.3P PS=13.2U PD=13.2U
* device instance $3 r0 *1 14.1,44.8 PMOS
M$3 Y \$5 VDD VDD PMOS L=1U W=10.2U AS=15.3P AD=28.56P PS=13.2U PD=26U
* device instance $4 r0 *1 6.1,6.8 NMOS
M$4 \$5 A VSS VSS NMOS L=1U W=3.4U AS=9.52P AD=5.1P PS=12.4U PD=6.4U
* device instance $5 r0 *1 10.1,6.8 NMOS
M$5 VSS B \$5 VSS NMOS L=1U W=3.4U AS=5.1P AD=5.1P PS=6.4U PD=6.4U
* device instance $6 r0 *1 14.1,6.8 NMOS
M$6 Y \$5 VSS VSS NMOS L=1U W=3.4U AS=5.1P AD=9.52P PS=6.4U PD=12.4U
.ENDS OR2

.SUBCKT OR3 Y A C B VDD VSS
* device instance $1 r0 *1 6.1,44.8 PMOS
M$1 \$7 B \$2 VDD PMOS L=1U W=10.2U AS=28.56P AD=15.3P PS=26U PD=13.2U
* device instance $2 r0 *1 10.1,44.8 PMOS
M$2 \$8 A \$7 VDD PMOS L=1U W=10.2U AS=15.3P AD=15.3P PS=13.2U PD=13.2U
* device instance $3 r0 *1 14.1,44.8 PMOS
M$3 VDD C \$8 VDD PMOS L=1U W=10.2U AS=15.3P AD=15.3P PS=13.2U PD=13.2U
* device instance $4 r0 *1 18.1,44.8 PMOS
M$4 Y \$2 VDD VDD PMOS L=1U W=10.2U AS=15.3P AD=28.56P PS=13.2U PD=26U
* device instance $5 r0 *1 6.1,6.8 NMOS
M$5 VSS B \$2 VSS NMOS L=1U W=3.4U AS=9.52P AD=5.1P PS=12.4U PD=6.4U
* device instance $6 r0 *1 10.1,6.8 NMOS
M$6 \$2 A VSS VSS NMOS L=1U W=3.4U AS=5.1P AD=5.1P PS=6.4U PD=6.4U
* device instance $7 r0 *1 14.1,6.8 NMOS
M$7 VSS C \$2 VSS NMOS L=1U W=3.4U AS=5.1P AD=5.1P PS=6.4U PD=6.4U
* device instance $8 r0 *1 18.1,6.8 NMOS
M$8 Y \$2 VSS VSS NMOS L=1U W=3.4U AS=5.1P AD=9.52P PS=6.4U PD=12.4U
.ENDS OR3

.SUBCKT OR4 Y D C B A VDD VSS
* device instance $1 r0 *1 6.1,44.8 PMOS
M$1 \$8 D \$2 VDD PMOS L=1U W=10.2U AS=28.56P AD=15.3P PS=26U PD=13.2U
* device instance $2 r0 *1 10.1,44.8 PMOS
M$2 \$9 C \$8 VDD PMOS L=1U W=10.2U AS=15.3P AD=15.3P PS=13.2U PD=13.2U
* device instance $3 r0 *1 14.1,44.8 PMOS
M$3 \$10 B \$9 VDD PMOS L=1U W=10.2U AS=15.3P AD=15.3P PS=13.2U PD=13.2U
* device instance $4 r0 *1 18.1,44.8 PMOS
M$4 VDD A \$10 VDD PMOS L=1U W=10.2U AS=15.3P AD=15.3P PS=13.2U PD=13.2U
* device instance $5 r0 *1 22.1,44.8 PMOS
M$5 Y \$2 VDD VDD PMOS L=1U W=10.2U AS=15.3P AD=28.56P PS=13.2U PD=26U
* device instance $6 r0 *1 6.1,6.8 NMOS
M$6 \$2 D VSS VSS NMOS L=1U W=3.4U AS=9.52P AD=5.1P PS=12.4U PD=6.4U
* device instance $7 r0 *1 10.1,6.8 NMOS
M$7 VSS C \$2 VSS NMOS L=1U W=3.4U AS=5.1P AD=5.1P PS=6.4U PD=6.4U
* device instance $8 r0 *1 14.1,6.8 NMOS
M$8 \$2 B VSS VSS NMOS L=1U W=3.4U AS=5.1P AD=5.1P PS=6.4U PD=6.4U
* device instance $9 r0 *1 18.1,6.8 NMOS
M$9 VSS A \$2 VSS NMOS L=1U W=3.4U AS=5.1P AD=5.1P PS=6.4U PD=6.4U
* device instance $10 r0 *1 22.1,6.8 NMOS
M$10 Y \$2 VSS VSS NMOS L=1U W=3.4U AS=5.1P AD=9.52P PS=6.4U PD=12.4U
.ENDS OR4

.SUBCKT XNOR2 B Y A VDD VSS
* device instance $1 r0 *1 18.1,44.8 PMOS
M$1 VDD \$4 Y VDD PMOS L=1U W=10.2U AS=28.56P AD=15.3P PS=26U PD=13.2U
* device instance $2 r0 *1 22.1,44.8 PMOS
M$2 \$9 B VDD VDD PMOS L=1U W=10.2U AS=15.3P AD=15.3P PS=13.2U PD=13.2U
* device instance $3 r0 *1 26.1,44.8 PMOS
M$3 Y A \$9 VDD PMOS L=1U W=10.2U AS=15.3P AD=28.56P PS=13.2U PD=26U
* device instance $4 r0 *1 6.1,44.8 PMOS
M$4 VDD A \$4 VDD PMOS L=1U W=10.2U AS=28.56P AD=15.3P PS=26U PD=13.2U
* device instance $5 r0 *1 10.1,44.8 PMOS
M$5 \$4 B VDD VDD PMOS L=1U W=10.2U AS=15.3P AD=28.56P PS=13.2U PD=26U
* device instance $6 r0 *1 18.1,6.8 NMOS
M$6 \$6 \$4 Y VSS NMOS L=1U W=3.4U AS=9.52P AD=5.1P PS=12.4U PD=6.4U
* device instance $7 r0 *1 22.1,6.8 NMOS
M$7 VSS B \$6 VSS NMOS L=1U W=3.4U AS=5.1P AD=5.1P PS=6.4U PD=6.4U
* device instance $8 r0 *1 26.1,6.8 NMOS
M$8 \$6 A VSS VSS NMOS L=1U W=3.4U AS=5.1P AD=9.52P PS=6.4U PD=12.4U
* device instance $9 r0 *1 6.1,6.8 NMOS
M$9 \$2 A VSS VSS NMOS L=1U W=3.4U AS=9.52P AD=5.1P PS=12.4U PD=6.4U
* device instance $10 r0 *1 10.1,6.8 NMOS
M$10 \$4 B \$2 VSS NMOS L=1U W=3.4U AS=5.1P AD=9.52P PS=6.4U PD=12.4U
.ENDS XNOR2

.SUBCKT XOR2 B Y A VDD VSS
* device instance $1 r0 *1 18.1,44.8 PMOS
M$1 \$9 \$2 Y VDD PMOS L=1U W=10.2U AS=28.56P AD=15.3P PS=26U PD=13.2U
* device instance $2 r0 *1 22.1,44.8 PMOS
M$2 VDD B \$9 VDD PMOS L=1U W=10.2U AS=15.3P AD=15.3P PS=13.2U PD=13.2U
* device instance $3 r0 *1 26.1,44.8 PMOS
M$3 \$9 A VDD VDD PMOS L=1U W=10.2U AS=15.3P AD=28.56P PS=13.2U PD=26U
* device instance $4 r0 *1 6.1,44.8 PMOS
M$4 \$8 A VDD VDD PMOS L=1U W=10.2U AS=28.56P AD=15.3P PS=26U PD=13.2U
* device instance $5 r0 *1 10.1,44.8 PMOS
M$5 \$2 B \$8 VDD PMOS L=1U W=10.2U AS=15.3P AD=28.56P PS=13.2U PD=26U
* device instance $6 r0 *1 18.1,6.8 NMOS
M$6 VSS \$2 Y VSS NMOS L=1U W=3.4U AS=9.52P AD=5.1P PS=12.4U PD=6.4U
* device instance $7 r0 *1 22.1,6.8 NMOS
M$7 \$5 B VSS VSS NMOS L=1U W=3.4U AS=5.1P AD=5.1P PS=6.4U PD=6.4U
* device instance $8 r0 *1 26.1,6.8 NMOS
M$8 Y A \$5 VSS NMOS L=1U W=3.4U AS=5.1P AD=9.52P PS=6.4U PD=12.4U
* device instance $9 r0 *1 6.1,6.8 NMOS
M$9 VSS A \$2 VSS NMOS L=1U W=3.4U AS=9.52P AD=5.1P PS=12.4U PD=6.4U
* device instance $10 r0 *1 10.1,6.8 NMOS
M$10 \$2 B VSS VSS NMOS L=1U W=3.4U AS=5.1P AD=9.52P PS=6.4U PD=12.4U
.ENDS XOR2

* TR10 engineering SF corner (slow NMOS + fast PMOS).
.include ../ip62_models_calibrated
.param vthMN=0.05 vthMNE=0.05 vthMP=0.05 vthMPE=0.05
.param magRR=1.0 magRS=1.0 magCSIO=1.0

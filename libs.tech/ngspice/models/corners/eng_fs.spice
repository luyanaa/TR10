* TR10 engineering FS corner (fast NMOS + slow PMOS).
.include ../ip62_models_calibrated
.param vthMN=-0.05 vthMNE=-0.05 vthMP=-0.05 vthMPE=-0.05
.param magRR=1.0 magRS=1.0 magCSIO=1.0

* SPICE3 file created from rx_amdemod.ext - technology: TR10

M1000 a_150_4580# d4 a_110_4580# Gnd nfet w=25u l=1u
+  ad=37.5p pd=28u as=37.5p ps=28u
M1001 a_150_2730# qq a_110_2730# Gnd nfet w=25u l=1u
+  ad=37.5p pd=28u as=37.5p ps=28u
M1002 a_70_2290# d2 a_30_2290# Gnd nfet w=25u l=1u
+  ad=37.5p pd=28u as=75p ps=56u
M1003 a_190_440# bi a_150_440# Gnd nfet w=25u l=1u
+  ad=75p pd=56u as=37.5p ps=28u
M1004 a_110_440# bi a_70_440# Gnd nfet w=25u l=1u
+  ad=37.5p pd=28u as=37.5p ps=28u
M1005 a_150_440# bi a_110_440# Gnd nfet w=25u l=1u
+  ad=37.5p pd=28u as=37.5p ps=28u
M1006 a_150_1850# d2 a_110_1850# Gnd nfet w=25u l=1u
+  ad=37.5p pd=28u as=37.5p ps=28u
M1007 a_180_880# d1 a_130_880# w_n45_805# pfet w=12.5u l=2u
+  ad=18.75p pd=15.5u as=18.75p ps=15.5u
M1008 a_230_880# d1 a_180_880# w_n45_805# pfet w=12.5u l=2u
+  ad=37.5p pd=31u as=18.75p ps=15.5u
M1009 a_110_0# ii a_70_0# Gnd nfet w=25u l=1u
+  ad=37.5p pd=28u as=37.5p ps=28u
M1010 a_190_5020# d4 a_150_5020# Gnd nfet w=25u l=1u
+  ad=75p pd=56u as=37.5p ps=28u
M1011 a_70_0# ii a_30_0# Gnd nfet w=25u l=1u
+  ad=37.5p pd=28u as=75p ps=56u
M1012 a_110_4580# d4 a_70_4580# Gnd nfet w=25u l=1u
+  ad=37.5p pd=28u as=37.5p ps=28u
M1013 a_110_2730# qq a_70_2730# Gnd nfet w=25u l=1u
+  ad=37.5p pd=28u as=37.5p ps=28u
M1014 a_70_440# bi tail Gnd nfet w=25u l=1u
+  ad=37.5p pd=28u as=75p ps=56u
M1015 a_80_3610# d3 a_30_3610# w_n45_3535# pfet w=12.5u l=2u
+  ad=18.75p pd=15.5u as=37.5p ps=31u
M1016 a_80_4095# d3 a_30_4095# w_n45_4020# pfet w=12.5u l=2u
+  ad=18.75p pd=15.5u as=37.5p ps=31u
M1017 a_70_2730# qq a_30_2730# Gnd nfet w=25u l=1u
+  ad=37.5p pd=28u as=75p ps=56u
M1018 a_70_4580# d4 a_30_4580# Gnd nfet w=25u l=1u
+  ad=37.5p pd=28u as=75p ps=56u
M1019 a_180_3610# d3 a_130_3610# w_n45_3535# pfet w=12.5u l=2u
+  ad=18.75p pd=15.5u as=18.75p ps=15.5u
M1020 a_110_1850# d2 a_70_1850# Gnd nfet w=25u l=1u
+  ad=37.5p pd=28u as=37.5p ps=28u
M1021 a_150_5020# d4 a_110_5020# Gnd nfet w=25u l=1u
+  ad=37.5p pd=28u as=37.5p ps=28u
M1022 a_180_4095# d3 a_130_4095# w_n45_4020# pfet w=12.5u l=2u
+  ad=18.75p pd=15.5u as=18.75p ps=15.5u
M1023 a_190_3170# bq a_150_3170# Gnd nfet w=25u l=1u
+  ad=75p pd=56u as=37.5p ps=28u
M1024 a_80_1365# d1 a_30_1365# w_n45_1290# pfet w=12.5u l=2u
+  ad=18.75p pd=15.5u as=37.5p ps=31u
M1025 a_130_880# d1 a_80_880# w_n45_805# pfet w=12.5u l=2u
+  ad=18.75p pd=15.5u as=18.75p ps=15.5u
M1026 a_70_1850# d2 a_30_1850# Gnd nfet w=25u l=1u
+  ad=37.5p pd=28u as=75p ps=56u
M1027 a_180_1365# d1 a_130_1365# w_n45_1290# pfet w=12.5u l=2u
+  ad=18.75p pd=15.5u as=18.75p ps=15.5u
M1028 a_190_2290# d2 a_150_2290# Gnd nfet w=25u l=1u
+  ad=75p pd=56u as=37.5p ps=28u
M1029 a_110_5020# d4 out Gnd nfet w=25u l=1u
+  ad=37.5p pd=28u as=37.5p ps=28u
M1030 a_230_3610# d3 a_180_3610# w_n45_3535# pfet w=12.5u l=2u
+  ad=37.5p pd=31u as=18.75p ps=15.5u
M1031 a_150_3170# bq a_110_3170# Gnd nfet w=25u l=1u
+  ad=37.5p pd=28u as=37.5p ps=28u
M1032 a_230_4095# d3 a_180_4095# w_n45_4020# pfet w=12.5u l=2u
+  ad=37.5p pd=31u as=18.75p ps=15.5u
M1033 out d4 a_30_5020# Gnd nfet w=25u l=1u
+  ad=37.5p pd=28u as=75p ps=56u
M1034 a_150_2290# d2 a_110_2290# Gnd nfet w=25u l=1u
+  ad=37.5p pd=28u as=37.5p ps=28u
M1035 a_230_1365# d1 a_180_1365# w_n45_1290# pfet w=12.5u l=2u
+  ad=37.5p pd=31u as=18.75p ps=15.5u
M1036 a_110_3170# bq a_70_3170# Gnd nfet w=25u l=1u
+  ad=37.5p pd=28u as=37.5p ps=28u
M1037 a_190_2730# qq a_150_2730# Gnd nfet w=25u l=1u
+  ad=75p pd=56u as=37.5p ps=28u
M1038 a_80_880# d1 a_30_880# w_n45_805# pfet w=12.5u l=2u
+  ad=18.75p pd=15.5u as=37.5p ps=31u
M1039 a_190_4580# d4 a_150_4580# Gnd nfet w=25u l=1u
+  ad=75p pd=56u as=37.5p ps=28u
M1040 a_130_3610# d3 a_80_3610# w_n45_3535# pfet w=12.5u l=2u
+  ad=18.75p pd=15.5u as=18.75p ps=15.5u
M1041 a_130_4095# d3 a_80_4095# w_n45_4020# pfet w=12.5u l=2u
+  ad=18.75p pd=15.5u as=18.75p ps=15.5u
M1042 a_190_0# ii a_150_0# Gnd nfet w=25u l=1u
+  ad=75p pd=56u as=37.5p ps=28u
M1043 a_70_3170# bq tailq Gnd nfet w=25u l=1u
+  ad=37.5p pd=28u as=75p ps=56u
M1044 a_110_2290# d2 a_70_2290# Gnd nfet w=25u l=1u
+  ad=37.5p pd=28u as=37.5p ps=28u
M1045 a_190_1850# d2 a_150_1850# Gnd nfet w=25u l=1u
+  ad=75p pd=56u as=37.5p ps=28u
M1046 a_130_1365# d1 a_80_1365# w_n45_1290# pfet w=12.5u l=2u
+  ad=18.75p pd=15.5u as=18.75p ps=15.5u
M1047 a_150_0# ii a_110_0# Gnd nfet w=25u l=1u
+  ad=37.5p pd=28u as=37.5p ps=28u
C0 d2 tail 0.2736f
C1 vss d2 0.2736f
C2 vdd d3 1.0944f
C3 d3 tailq 0.5472f
C4 d1 bi 0.2736f
C5 d4 d3 0.5472f
C6 d3 qq 0.2736f
C7 vss bq 0.2736f
C8 out vdd 0.2736f
C9 out tailq 0.5472f
C10 d4 out 1.0944f
C11 out qq 0.2736f
C12 d2 bi 0.2736f
C13 vdd d1 0.2736f
C14 d3 bq 0.2736f
C15 vdd tailq 0.5472f
C16 out d2 0.2736f
C17 vss d3 1.0944f
C18 d4 vdd 0.5472f
C19 vdd qq 0.2736f
C20 bi tail 0.2736f
C21 d4 tailq 0.2736f
C22 out bq 0.2736f
C23 vss out 0.5472f
C24 d2 d1 0.5472f
C25 vdd d2 0.5472f
C26 d1 tail 0.5472f
C27 vdd bq 0.2736f
C28 vss vdd 0.5472f
C29 d1 ii 0.2736f
C30 bq tailq 0.2736f
C31 vss tailq 0.5472f
C32 d4 bq 0.2736f
C33 vss d4 1.368f
C34 out d3 1.0944f
C35 vss qq 0.2736f
C36 a_190_0# 0 3.49f **FLOATING
C37 a_150_0# 0 2.49f **FLOATING
C38 a_110_0# 0 2.49f **FLOATING
C39 a_70_0# 0 2.49f **FLOATING
C40 a_30_0# 0 3.49f **FLOATING
C41 ii 0 19.5986f **FLOATING
C42 a_190_440# 0 3.49f **FLOATING
C43 a_150_440# 0 2.49f **FLOATING
C44 a_110_440# 0 2.49f **FLOATING
C45 a_70_440# 0 2.49f **FLOATING
C46 tail 0 72.76421f **FLOATING
C47 bi 0 23.6666f **FLOATING
C48 a_230_880# 0 1.865f **FLOATING
C49 a_180_880# 0 1.365f **FLOATING
C50 a_130_880# 0 1.365f **FLOATING
C51 a_80_880# 0 1.365f **FLOATING
C52 a_30_880# 0 1.865f **FLOATING
C53 a_290_1081# 0 0.6188f **FLOATING
C54 a_230_1365# 0 1.865f **FLOATING
C55 a_180_1365# 0 1.365f **FLOATING
C56 a_130_1365# 0 1.365f **FLOATING
C57 a_80_1365# 0 1.365f **FLOATING
C58 a_30_1365# 0 1.865f **FLOATING
C59 d1 0 97.3863f **FLOATING
C60 a_290_1566# 0 0.6188f **FLOATING
C61 a_190_1850# 0 3.49f **FLOATING
C62 a_150_1850# 0 2.49f **FLOATING
C63 a_110_1850# 0 2.49f **FLOATING
C64 a_70_1850# 0 2.49f **FLOATING
C65 a_30_1850# 0 3.49f **FLOATING
C66 a_190_2290# 0 3.49f **FLOATING
C67 a_150_2290# 0 2.49f **FLOATING
C68 a_110_2290# 0 2.49f **FLOATING
C69 a_70_2290# 0 2.49f **FLOATING
C70 a_30_2290# 0 3.49f **FLOATING
C71 d2 0 0.14571p **FLOATING
C72 a_190_2730# 0 3.49f **FLOATING
C73 a_150_2730# 0 2.49f **FLOATING
C74 a_110_2730# 0 2.49f **FLOATING
C75 a_70_2730# 0 2.49f **FLOATING
C76 a_30_2730# 0 3.49f **FLOATING
C77 qq 0 30.4466f **FLOATING
C78 a_190_3170# 0 3.49f **FLOATING
C79 a_150_3170# 0 2.49f **FLOATING
C80 a_110_3170# 0 2.49f **FLOATING
C81 a_70_3170# 0 2.49f **FLOATING
C82 tailq 0 94.46021f **FLOATING
C83 bq 0 34.5146f **FLOATING
C84 a_230_3610# 0 1.865f **FLOATING
C85 a_180_3610# 0 1.365f **FLOATING
C86 a_130_3610# 0 1.365f **FLOATING
C87 a_80_3610# 0 1.365f **FLOATING
C88 a_30_3610# 0 1.865f **FLOATING
C89 a_290_3811# 0 0.6188f **FLOATING
C90 a_230_4095# 0 1.865f **FLOATING
C91 a_180_4095# 0 1.365f **FLOATING
C92 a_130_4095# 0 1.365f **FLOATING
C93 a_80_4095# 0 1.365f **FLOATING
C94 a_30_4095# 0 1.865f **FLOATING
C95 d3 0 0.14102p **FLOATING
C96 vdd 0 0.16369p
C97 a_190_4580# 0 3.49f **FLOATING
C98 a_150_4580# 0 2.49f **FLOATING
C99 a_110_4580# 0 2.49f **FLOATING
C100 a_70_4580# 0 2.49f **FLOATING
C101 a_30_4580# 0 3.49f **FLOATING
C102 a_190_5020# 0 3.49f **FLOATING
C103 a_150_5020# 0 2.49f **FLOATING
C104 a_110_5020# 0 2.49f **FLOATING
C105 out 0 0.10511p **FLOATING
C106 a_30_5020# 0 3.49f **FLOATING
C107 d4 0 0.20094p **FLOATING
C108 vss 0 0.20796p

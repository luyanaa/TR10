* Strict LVS contract for rx_vco (generated with the layout)
.SUBCKT rx_vco out_p out_n vtune tail vss
M1 out_p out_n tail vss NMOS w=200.0u l=1.0u
M2 out_n out_p tail vss NMOS w=200.0u l=1.0u
M3 out_p vtune out_p vss NMOS w=9600.0u l=1.0u
M4 out_n vtune out_n vss NMOS w=9600.0u l=1.0u
.ENDS

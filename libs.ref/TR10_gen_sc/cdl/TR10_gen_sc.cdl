* TR10 standard-cell CDL (from STDLIB LogicCells extracted)
*
* ==== AND2_X1 ====
* Created by KLayout

* cell AND2_X1
* pin A
* pin B
* pin VDD
* pin Y
* pin GND
.SUBCKT AND2_X1 A B VDD Y GND
* device instance $1 r0 *1 6.1,44.8 PMOS
M$1 \$6 A VDD VDD PMOS L=1U W=10.2U AS=28.56P AD=15.3P PS=26U PD=13.2U
* device instance $2 r0 *1 10.1,44.8 PMOS
M$2 VDD B \$6 VDD PMOS L=1U W=10.2U AS=15.3P AD=15.3P PS=13.2U PD=13.2U
* device instance $3 r0 *1 14.1,44.8 PMOS
M$3 Y \$6 VDD VDD PMOS L=1U W=10.2U AS=15.3P AD=28.56P PS=13.2U PD=26U
* device instance $4 r0 *1 6.1,6.8 NMOS
M$4 \$4 A \$6 GND NMOS L=1U W=3.4U AS=9.52P AD=5.1P PS=12.4U PD=6.4U
* device instance $5 r0 *1 10.1,6.8 NMOS
M$5 GND B \$4 GND NMOS L=1U W=3.4U AS=5.1P AD=5.1P PS=6.4U PD=6.4U
* device instance $6 r0 *1 14.1,6.8 NMOS
M$6 Y \$6 GND GND NMOS L=1U W=3.4U AS=5.1P AD=9.52P PS=6.4U PD=12.4U
.ENDS AND2_X1

* ==== AND3_X1 ====
* Created by KLayout

* cell AND3_X1
* pin A
* pin B
* pin Y
* pin C
* pin VDD
* pin GND
.SUBCKT AND3_X1 A B Y C VDD GND
* device instance $1 r0 *1 6.1,44.8 PMOS
M$1 VDD A \$3 VDD PMOS L=1U W=10.2U AS=28.56P AD=15.3P PS=26U PD=13.2U
* device instance $2 r0 *1 10.1,44.8 PMOS
M$2 \$3 B VDD VDD PMOS L=1U W=10.2U AS=15.3P AD=15.3P PS=13.2U PD=13.2U
* device instance $3 r0 *1 14.1,44.8 PMOS
M$3 VDD C \$3 VDD PMOS L=1U W=10.2U AS=15.3P AD=15.3P PS=13.2U PD=13.2U
* device instance $4 r0 *1 18.1,44.8 PMOS
M$4 Y \$3 VDD VDD PMOS L=1U W=10.2U AS=15.3P AD=28.56P PS=13.2U PD=26U
* device instance $5 r0 *1 6.1,6.8 NMOS
M$5 \$5 A \$3 GND NMOS L=1U W=3.4U AS=9.52P AD=5.1P PS=12.4U PD=6.4U
* device instance $6 r0 *1 10.1,6.8 NMOS
M$6 \$6 B \$5 GND NMOS L=1U W=3.4U AS=5.1P AD=5.1P PS=6.4U PD=6.4U
* device instance $7 r0 *1 14.1,6.8 NMOS
M$7 GND C \$6 GND NMOS L=1U W=3.4U AS=5.1P AD=5.1P PS=6.4U PD=6.4U
* device instance $8 r0 *1 18.1,6.8 NMOS
M$8 Y \$3 GND GND NMOS L=1U W=3.4U AS=5.1P AD=9.52P PS=6.4U PD=12.4U
.ENDS AND3_X1

* ==== AND4_X1 ====
* Created by KLayout

* cell AND4_X1
* pin A
* pin C
* pin Y
* pin B
* pin D
* pin VDD
* pin GND
.SUBCKT AND4_X1 A C Y B D VDD GND
* device instance $1 r0 *1 6.1,44.8 PMOS
M$1 \$2 A VDD VDD PMOS L=1U W=10.2U AS=28.56P AD=15.3P PS=26U PD=13.2U
* device instance $2 r0 *1 10.1,44.8 PMOS
M$2 VDD B \$2 VDD PMOS L=1U W=10.2U AS=15.3P AD=15.3P PS=13.2U PD=13.2U
* device instance $3 r0 *1 14.1,44.8 PMOS
M$3 \$2 C VDD VDD PMOS L=1U W=10.2U AS=15.3P AD=15.3P PS=13.2U PD=13.2U
* device instance $4 r0 *1 18.1,44.8 PMOS
M$4 VDD D \$2 VDD PMOS L=1U W=10.2U AS=15.3P AD=15.3P PS=13.2U PD=13.2U
* device instance $5 r0 *1 22.1,44.8 PMOS
M$5 Y \$2 VDD VDD PMOS L=1U W=10.2U AS=15.3P AD=28.56P PS=13.2U PD=26U
* device instance $6 r0 *1 6.1,6.8 NMOS
M$6 \$4 A \$2 GND NMOS L=1U W=3.4U AS=9.52P AD=5.1P PS=12.4U PD=6.4U
* device instance $7 r0 *1 10.1,6.8 NMOS
M$7 \$5 B \$4 GND NMOS L=1U W=3.4U AS=5.1P AD=5.1P PS=6.4U PD=6.4U
* device instance $8 r0 *1 14.1,6.8 NMOS
M$8 \$7 C \$5 GND NMOS L=1U W=3.4U AS=5.1P AD=5.1P PS=6.4U PD=6.4U
* device instance $9 r0 *1 18.1,6.8 NMOS
M$9 GND D \$7 GND NMOS L=1U W=3.4U AS=5.1P AD=5.1P PS=6.4U PD=6.4U
* device instance $10 r0 *1 22.1,6.8 NMOS
M$10 Y \$2 GND GND NMOS L=1U W=3.4U AS=5.1P AD=9.52P PS=6.4U PD=12.4U
.ENDS AND4_X1

* ==== BUF_X1 ====
* Created by KLayout

* cell BUF_X1
* pin A
* pin VDD
* pin Y
* pin GND
.SUBCKT BUF_X1 A VDD Y GND
* device instance $1 r0 *1 6.1,44.8 PMOS
M$1 VDD A \$2 VDD PMOS L=1U W=10.2U AS=28.56P AD=15.3P PS=26U PD=13.2U
* device instance $2 r0 *1 10.1,44.8 PMOS
M$2 Y \$2 VDD VDD PMOS L=1U W=10.2U AS=15.3P AD=28.56P PS=13.2U PD=26U
* device instance $3 r0 *1 6.1,6.8 NMOS
M$3 GND A \$2 GND NMOS L=1U W=3.4U AS=9.52P AD=5.1P PS=12.4U PD=6.4U
* device instance $4 r0 *1 10.1,6.8 NMOS
M$4 Y \$2 GND GND NMOS L=1U W=3.4U AS=5.1P AD=9.52P PS=6.4U PD=12.4U
.ENDS BUF_X1

* ==== BUF_X12 ====
* Created by KLayout

* cell BUF_X12
* pin A
* pin Y
* pin VDD
* pin GND
.SUBCKT BUF_X12 A Y VDD GND
* device instance $1 r0 *1 6.1,44.8 PMOS
M$1 \$3 A VDD VDD PMOS L=1U W=10.2U AS=28.56P AD=15.3P PS=26U PD=13.2U
* device instance $2 r0 *1 10.1,44.8 PMOS
M$2 VDD A \$3 VDD PMOS L=1U W=10.2U AS=15.3P AD=15.3P PS=13.2U PD=13.2U
* device instance $3 r0 *1 14.1,44.8 PMOS
M$3 Y \$3 VDD VDD PMOS L=1U W=10.2U AS=15.3P AD=15.3P PS=13.2U PD=13.2U
* device instance $4 r0 *1 18.1,44.8 PMOS
M$4 VDD \$3 Y VDD PMOS L=1U W=10.2U AS=15.3P AD=15.3P PS=13.2U PD=13.2U
* device instance $5 r0 *1 22.1,44.8 PMOS
M$5 Y \$3 VDD VDD PMOS L=1U W=10.2U AS=15.3P AD=15.3P PS=13.2U PD=13.2U
* device instance $6 r0 *1 26.1,44.8 PMOS
M$6 VDD \$3 Y VDD PMOS L=1U W=10.2U AS=15.3P AD=15.3P PS=13.2U PD=13.2U
* device instance $7 r0 *1 30.1,44.8 PMOS
M$7 Y \$3 VDD VDD PMOS L=1U W=10.2U AS=15.3P AD=15.3P PS=13.2U PD=13.2U
* device instance $8 r0 *1 34.1,44.8 PMOS
M$8 VDD \$3 Y VDD PMOS L=1U W=10.2U AS=15.3P AD=15.3P PS=13.2U PD=13.2U
* device instance $9 r0 *1 38.1,44.8 PMOS
M$9 Y \$3 VDD VDD PMOS L=1U W=10.2U AS=15.3P AD=15.3P PS=13.2U PD=13.2U
* device instance $10 r0 *1 42.1,44.8 PMOS
M$10 VDD \$3 Y VDD PMOS L=1U W=10.2U AS=15.3P AD=15.3P PS=13.2U PD=13.2U
* device instance $11 r0 *1 46.1,44.8 PMOS
M$11 Y \$3 VDD VDD PMOS L=1U W=10.2U AS=15.3P AD=15.3P PS=13.2U PD=13.2U
* device instance $12 r0 *1 50.1,44.8 PMOS
M$12 VDD \$3 Y VDD PMOS L=1U W=10.2U AS=15.3P AD=15.3P PS=13.2U PD=13.2U
* device instance $13 r0 *1 54.1,44.8 PMOS
M$13 Y \$3 VDD VDD PMOS L=1U W=10.2U AS=15.3P AD=15.3P PS=13.2U PD=13.2U
* device instance $14 r0 *1 58.1,44.8 PMOS
M$14 VDD \$3 Y VDD PMOS L=1U W=10.2U AS=15.3P AD=28.56P PS=13.2U PD=26U
* device instance $15 r0 *1 6.1,6.8 NMOS
M$15 \$3 A GND GND NMOS L=1U W=3.4U AS=9.52P AD=5.1P PS=12.4U PD=6.4U
* device instance $16 r0 *1 10.1,6.8 NMOS
M$16 GND A \$3 GND NMOS L=1U W=3.4U AS=5.1P AD=5.1P PS=6.4U PD=6.4U
* device instance $17 r0 *1 14.1,6.8 NMOS
M$17 Y \$3 GND GND NMOS L=1U W=3.4U AS=5.1P AD=5.1P PS=6.4U PD=6.4U
* device instance $18 r0 *1 18.1,6.8 NMOS
M$18 GND \$3 Y GND NMOS L=1U W=3.4U AS=5.1P AD=5.1P PS=6.4U PD=6.4U
* device instance $19 r0 *1 22.1,6.8 NMOS
M$19 Y \$3 GND GND NMOS L=1U W=3.4U AS=5.1P AD=5.1P PS=6.4U PD=6.4U
* device instance $20 r0 *1 26.1,6.8 NMOS
M$20 GND \$3 Y GND NMOS L=1U W=3.4U AS=5.1P AD=5.1P PS=6.4U PD=6.4U
* device instance $21 r0 *1 30.1,6.8 NMOS
M$21 Y \$3 GND GND NMOS L=1U W=3.4U AS=5.1P AD=5.1P PS=6.4U PD=6.4U
* device instance $22 r0 *1 34.1,6.8 NMOS
M$22 GND \$3 Y GND NMOS L=1U W=3.4U AS=5.1P AD=5.1P PS=6.4U PD=6.4U
* device instance $23 r0 *1 38.1,6.8 NMOS
M$23 Y \$3 GND GND NMOS L=1U W=3.4U AS=5.1P AD=5.1P PS=6.4U PD=6.4U
* device instance $24 r0 *1 42.1,6.8 NMOS
M$24 GND \$3 Y GND NMOS L=1U W=3.4U AS=5.1P AD=5.1P PS=6.4U PD=6.4U
* device instance $25 r0 *1 46.1,6.8 NMOS
M$25 Y \$3 GND GND NMOS L=1U W=3.4U AS=5.1P AD=5.1P PS=6.4U PD=6.4U
* device instance $26 r0 *1 50.1,6.8 NMOS
M$26 GND \$3 Y GND NMOS L=1U W=3.4U AS=5.1P AD=5.1P PS=6.4U PD=6.4U
* device instance $27 r0 *1 54.1,6.8 NMOS
M$27 Y \$3 GND GND NMOS L=1U W=3.4U AS=5.1P AD=5.1P PS=6.4U PD=6.4U
* device instance $28 r0 *1 58.1,6.8 NMOS
M$28 GND \$3 Y GND NMOS L=1U W=3.4U AS=5.1P AD=9.52P PS=6.4U PD=12.4U
.ENDS BUF_X12

* ==== BUF_X16 ====
* Created by KLayout

* cell BUF_X16
* pin Y
* pin A
* pin VDD
* pin GND
.SUBCKT BUF_X16 Y A VDD GND
* device instance $1 r0 *1 26.1,44.8 PMOS
M$1 Y \$4 VDD VDD PMOS L=1U W=10.2U AS=28.56P AD=15.3P PS=26U PD=13.2U
* device instance $2 r0 *1 30.1,44.8 PMOS
M$2 VDD \$4 Y VDD PMOS L=1U W=10.2U AS=15.3P AD=15.3P PS=13.2U PD=13.2U
* device instance $3 r0 *1 34.1,44.8 PMOS
M$3 Y \$4 VDD VDD PMOS L=1U W=10.2U AS=15.3P AD=15.3P PS=13.2U PD=13.2U
* device instance $4 r0 *1 38.1,44.8 PMOS
M$4 VDD \$4 Y VDD PMOS L=1U W=10.2U AS=15.3P AD=15.3P PS=13.2U PD=13.2U
* device instance $5 r0 *1 42.1,44.8 PMOS
M$5 Y \$4 VDD VDD PMOS L=1U W=10.2U AS=15.3P AD=15.3P PS=13.2U PD=13.2U
* device instance $6 r0 *1 46.1,44.8 PMOS
M$6 VDD \$4 Y VDD PMOS L=1U W=10.2U AS=15.3P AD=15.3P PS=13.2U PD=13.2U
* device instance $7 r0 *1 50.1,44.8 PMOS
M$7 Y \$4 VDD VDD PMOS L=1U W=10.2U AS=15.3P AD=15.3P PS=13.2U PD=13.2U
* device instance $8 r0 *1 54.1,44.8 PMOS
M$8 VDD \$4 Y VDD PMOS L=1U W=10.2U AS=15.3P AD=15.3P PS=13.2U PD=13.2U
* device instance $9 r0 *1 58.1,44.8 PMOS
M$9 Y \$4 VDD VDD PMOS L=1U W=10.2U AS=15.3P AD=15.3P PS=13.2U PD=13.2U
* device instance $10 r0 *1 62.1,44.8 PMOS
M$10 VDD \$4 Y VDD PMOS L=1U W=10.2U AS=15.3P AD=15.3P PS=13.2U PD=13.2U
* device instance $11 r0 *1 66.1,44.8 PMOS
M$11 Y \$4 VDD VDD PMOS L=1U W=10.2U AS=15.3P AD=15.3P PS=13.2U PD=13.2U
* device instance $12 r0 *1 70.1,44.8 PMOS
M$12 VDD \$4 Y VDD PMOS L=1U W=10.2U AS=15.3P AD=15.3P PS=13.2U PD=13.2U
* device instance $13 r0 *1 74.1,44.8 PMOS
M$13 Y \$4 VDD VDD PMOS L=1U W=10.2U AS=15.3P AD=15.3P PS=13.2U PD=13.2U
* device instance $14 r0 *1 78.1,44.8 PMOS
M$14 VDD \$4 Y VDD PMOS L=1U W=10.2U AS=15.3P AD=15.3P PS=13.2U PD=13.2U
* device instance $15 r0 *1 82.1,44.8 PMOS
M$15 Y \$4 VDD VDD PMOS L=1U W=10.2U AS=15.3P AD=15.3P PS=13.2U PD=13.2U
* device instance $16 r0 *1 86.1,44.8 PMOS
M$16 VDD \$4 Y VDD PMOS L=1U W=10.2U AS=15.3P AD=28.56P PS=13.2U PD=26U
* device instance $17 r0 *1 6.1,46.5 PMOS
M$17 \$4 A VDD VDD PMOS L=1U W=6.8U AS=19.04P AD=10.2P PS=19.2U PD=9.8U
* device instance $18 r0 *1 10.1,46.5 PMOS
M$18 VDD A \$4 VDD PMOS L=1U W=6.8U AS=10.2P AD=10.2P PS=9.8U PD=9.8U
* device instance $19 r0 *1 14.1,46.5 PMOS
M$19 \$4 A VDD VDD PMOS L=1U W=6.8U AS=10.2P AD=10.2P PS=9.8U PD=9.8U
* device instance $20 r0 *1 18.1,46.5 PMOS
M$20 VDD A \$4 VDD PMOS L=1U W=6.8U AS=10.2P AD=19.04P PS=9.8U PD=19.2U
* device instance $21 r0 *1 26.1,6.8 NMOS
M$21 Y \$4 GND GND NMOS L=1U W=3.4U AS=9.52P AD=5.1P PS=12.4U PD=6.4U
* device instance $22 r0 *1 30.1,6.8 NMOS
M$22 GND \$4 Y GND NMOS L=1U W=3.4U AS=5.1P AD=5.1P PS=6.4U PD=6.4U
* device instance $23 r0 *1 34.1,6.8 NMOS
M$23 Y \$4 GND GND NMOS L=1U W=3.4U AS=5.1P AD=5.1P PS=6.4U PD=6.4U
* device instance $24 r0 *1 38.1,6.8 NMOS
M$24 GND \$4 Y GND NMOS L=1U W=3.4U AS=5.1P AD=5.1P PS=6.4U PD=6.4U
* device instance $25 r0 *1 42.1,6.8 NMOS
M$25 Y \$4 GND GND NMOS L=1U W=3.4U AS=5.1P AD=5.1P PS=6.4U PD=6.4U
* device instance $26 r0 *1 46.1,6.8 NMOS
M$26 GND \$4 Y GND NMOS L=1U W=3.4U AS=5.1P AD=5.1P PS=6.4U PD=6.4U
* device instance $27 r0 *1 50.1,6.8 NMOS
M$27 Y \$4 GND GND NMOS L=1U W=3.4U AS=5.1P AD=5.1P PS=6.4U PD=6.4U
* device instance $28 r0 *1 54.1,6.8 NMOS
M$28 GND \$4 Y GND NMOS L=1U W=3.4U AS=5.1P AD=5.1P PS=6.4U PD=6.4U
* device instance $29 r0 *1 58.1,6.8 NMOS
M$29 Y \$4 GND GND NMOS L=1U W=3.4U AS=5.1P AD=5.1P PS=6.4U PD=6.4U
* device instance $30 r0 *1 62.1,6.8 NMOS
M$30 GND \$4 Y GND NMOS L=1U W=3.4U AS=5.1P AD=5.1P PS=6.4U PD=6.4U
* device instance $31 r0 *1 66.1,6.8 NMOS
M$31 Y \$4 GND GND NMOS L=1U W=3.4U AS=5.1P AD=5.1P PS=6.4U PD=6.4U
* device instance $32 r0 *1 70.1,6.8 NMOS
M$32 GND \$4 Y GND NMOS L=1U W=3.4U AS=5.1P AD=5.1P PS=6.4U PD=6.4U
* device instance $33 r0 *1 74.1,6.8 NMOS
M$33 Y \$4 GND GND NMOS L=1U W=3.4U AS=5.1P AD=5.1P PS=6.4U PD=6.4U
* device instance $34 r0 *1 78.1,6.8 NMOS
M$34 GND \$4 Y GND NMOS L=1U W=3.4U AS=5.1P AD=5.1P PS=6.4U PD=6.4U
* device instance $35 r0 *1 82.1,6.8 NMOS
M$35 Y \$4 GND GND NMOS L=1U W=3.4U AS=5.1P AD=5.1P PS=6.4U PD=6.4U
* device instance $36 r0 *1 86.1,6.8 NMOS
M$36 GND \$4 Y GND NMOS L=1U W=3.4U AS=5.1P AD=9.52P PS=6.4U PD=12.4U
* device instance $37 r0 *1 6.1,6.8 NMOS
M$37 \$4 A GND GND NMOS L=1U W=3.4U AS=9.52P AD=5.1P PS=12.4U PD=6.4U
* device instance $38 r0 *1 10.1,6.8 NMOS
M$38 GND A \$4 GND NMOS L=1U W=3.4U AS=5.1P AD=5.1P PS=6.4U PD=6.4U
* device instance $39 r0 *1 14.1,6.8 NMOS
M$39 \$4 A GND GND NMOS L=1U W=3.4U AS=5.1P AD=5.1P PS=6.4U PD=6.4U
* device instance $40 r0 *1 18.1,6.8 NMOS
M$40 GND A \$4 GND NMOS L=1U W=3.4U AS=5.1P AD=9.52P PS=6.4U PD=12.4U
.ENDS BUF_X16

* ==== BUF_X2 ====
* Created by KLayout

* cell BUF_X2
* pin A
* pin VDD
* pin Y
* pin GND
.SUBCKT BUF_X2 A VDD Y GND
* device instance $1 r0 *1 6.1,44.8 PMOS
M$1 VDD A \$3 VDD PMOS L=1U W=10.2U AS=28.56P AD=15.3P PS=26U PD=13.2U
* device instance $2 r0 *1 10.1,44.8 PMOS
M$2 Y \$3 VDD VDD PMOS L=1U W=10.2U AS=15.3P AD=15.3P PS=13.2U PD=13.2U
* device instance $3 r0 *1 14.1,44.8 PMOS
M$3 VDD \$3 Y VDD PMOS L=1U W=10.2U AS=15.3P AD=28.56P PS=13.2U PD=26U
* device instance $4 r0 *1 6.1,6.8 NMOS
M$4 GND A \$3 GND NMOS L=1U W=3.4U AS=9.52P AD=5.1P PS=12.4U PD=6.4U
* device instance $5 r0 *1 10.1,6.8 NMOS
M$5 Y \$3 GND GND NMOS L=1U W=3.4U AS=5.1P AD=5.1P PS=6.4U PD=6.4U
* device instance $6 r0 *1 14.1,6.8 NMOS
M$6 GND \$3 Y GND NMOS L=1U W=3.4U AS=5.1P AD=9.52P PS=6.4U PD=12.4U
.ENDS BUF_X2

* ==== BUF_X4 ====
* Created by KLayout

* cell BUF_X4
* pin A
* pin Y
* pin VDD
* pin VSS
.SUBCKT BUF_X4 A Y VDD GND
* device instance $1 r0 *1 6.1,44.8 PMOS
M$1 \$3 A VDD VDD PMOS L=1U W=10.2U AS=28.56P AD=15.3P PS=26U PD=13.2U
* device instance $2 r0 *1 10.1,44.8 PMOS
M$2 VDD A \$3 VDD PMOS L=1U W=10.2U AS=15.3P AD=15.3P PS=13.2U PD=13.2U
* device instance $3 r0 *1 14.1,44.8 PMOS
M$3 Y \$3 VDD VDD PMOS L=1U W=10.2U AS=15.3P AD=15.3P PS=13.2U PD=13.2U
* device instance $4 r0 *1 18.1,44.8 PMOS
M$4 VDD \$3 Y VDD PMOS L=1U W=10.2U AS=15.3P AD=15.3P PS=13.2U PD=13.2U
* device instance $5 r0 *1 22.1,44.8 PMOS
M$5 Y \$3 VDD VDD PMOS L=1U W=10.2U AS=15.3P AD=15.3P PS=13.2U PD=13.2U
* device instance $6 r0 *1 26.1,44.8 PMOS
M$6 VDD \$3 Y VDD PMOS L=1U W=10.2U AS=15.3P AD=28.56P PS=13.2U PD=26U
* device instance $7 r0 *1 6.1,6.8 NMOS
M$7 \$3 A GND GND NMOS L=1U W=3.4U AS=9.52P AD=5.1P PS=12.4U PD=6.4U
* device instance $8 r0 *1 10.1,6.8 NMOS
M$8 GND A \$3 GND NMOS L=1U W=3.4U AS=5.1P AD=5.1P PS=6.4U PD=6.4U
* device instance $9 r0 *1 14.1,6.8 NMOS
M$9 Y \$3 GND GND NMOS L=1U W=3.4U AS=5.1P AD=5.1P PS=6.4U PD=6.4U
* device instance $10 r0 *1 18.1,6.8 NMOS
M$10 GND \$3 Y GND NMOS L=1U W=3.4U AS=5.1P AD=5.1P PS=6.4U PD=6.4U
* device instance $11 r0 *1 22.1,6.8 NMOS
M$11 Y \$3 GND GND NMOS L=1U W=3.4U AS=5.1P AD=5.1P PS=6.4U PD=6.4U
* device instance $12 r0 *1 26.1,6.8 NMOS
M$12 GND \$3 Y GND NMOS L=1U W=3.4U AS=5.1P AD=9.52P PS=6.4U PD=12.4U
.ENDS BUF_X4

* ==== BUF_X8 ====
* Created by KLayout

* cell BUF_X8
* pin A
* pin Y
* pin VDD
* pin VSS
.SUBCKT BUF_X8 A Y VDD GND
* device instance $1 r0 *1 6.1,44.8 PMOS
M$1 \$3 A VDD VDD PMOS L=1U W=10.2U AS=28.56P AD=15.3P PS=26U PD=13.2U
* device instance $2 r0 *1 10.1,44.8 PMOS
M$2 VDD A \$3 VDD PMOS L=1U W=10.2U AS=15.3P AD=15.3P PS=13.2U PD=13.2U
* device instance $3 r0 *1 14.1,44.8 PMOS
M$3 Y \$3 VDD VDD PMOS L=1U W=10.2U AS=15.3P AD=15.3P PS=13.2U PD=13.2U
* device instance $4 r0 *1 18.1,44.8 PMOS
M$4 VDD \$3 Y VDD PMOS L=1U W=10.2U AS=15.3P AD=15.3P PS=13.2U PD=13.2U
* device instance $5 r0 *1 22.1,44.8 PMOS
M$5 Y \$3 VDD VDD PMOS L=1U W=10.2U AS=15.3P AD=15.3P PS=13.2U PD=13.2U
* device instance $6 r0 *1 26.1,44.8 PMOS
M$6 VDD \$3 Y VDD PMOS L=1U W=10.2U AS=15.3P AD=15.3P PS=13.2U PD=13.2U
* device instance $7 r0 *1 30.1,44.8 PMOS
M$7 Y \$3 VDD VDD PMOS L=1U W=10.2U AS=15.3P AD=15.3P PS=13.2U PD=13.2U
* device instance $8 r0 *1 34.1,44.8 PMOS
M$8 VDD \$3 Y VDD PMOS L=1U W=10.2U AS=15.3P AD=15.3P PS=13.2U PD=13.2U
* device instance $9 r0 *1 38.1,44.8 PMOS
M$9 Y \$3 VDD VDD PMOS L=1U W=10.2U AS=15.3P AD=15.3P PS=13.2U PD=13.2U
* device instance $10 r0 *1 42.1,44.8 PMOS
M$10 VDD \$3 Y VDD PMOS L=1U W=10.2U AS=15.3P AD=28.56P PS=13.2U PD=26U
* device instance $11 r0 *1 6.1,6.8 NMOS
M$11 \$3 A GND GND NMOS L=1U W=3.4U AS=9.52P AD=5.1P PS=12.4U PD=6.4U
* device instance $12 r0 *1 10.1,6.8 NMOS
M$12 GND A \$3 GND NMOS L=1U W=3.4U AS=5.1P AD=5.1P PS=6.4U PD=6.4U
* device instance $13 r0 *1 14.1,6.8 NMOS
M$13 Y \$3 GND GND NMOS L=1U W=3.4U AS=5.1P AD=5.1P PS=6.4U PD=6.4U
* device instance $14 r0 *1 18.1,6.8 NMOS
M$14 GND \$3 Y GND NMOS L=1U W=3.4U AS=5.1P AD=5.1P PS=6.4U PD=6.4U
* device instance $15 r0 *1 22.1,6.8 NMOS
M$15 Y \$3 GND GND NMOS L=1U W=3.4U AS=5.1P AD=5.1P PS=6.4U PD=6.4U
* device instance $16 r0 *1 26.1,6.8 NMOS
M$16 GND \$3 Y GND NMOS L=1U W=3.4U AS=5.1P AD=5.1P PS=6.4U PD=6.4U
* device instance $17 r0 *1 30.1,6.8 NMOS
M$17 Y \$3 GND GND NMOS L=1U W=3.4U AS=5.1P AD=5.1P PS=6.4U PD=6.4U
* device instance $18 r0 *1 34.1,6.8 NMOS
M$18 GND \$3 Y GND NMOS L=1U W=3.4U AS=5.1P AD=5.1P PS=6.4U PD=6.4U
* device instance $19 r0 *1 38.1,6.8 NMOS
M$19 Y \$3 GND GND NMOS L=1U W=3.4U AS=5.1P AD=5.1P PS=6.4U PD=6.4U
* device instance $20 r0 *1 42.1,6.8 NMOS
M$20 GND \$3 Y GND NMOS L=1U W=3.4U AS=5.1P AD=9.52P PS=6.4U PD=12.4U
.ENDS BUF_X8

* ==== CLKBUF_X1 ====
* Created by KLayout

* cell CLKBUF_X1
* pin A
* pin Y
* pin VDD
* pin GND
.SUBCKT CLKBUF_X1 A Y VDD GND
* device instance $1 r0 *1 6.1,44.8 PMOS
M$1 \$3 A VDD VDD PMOS L=1U W=10.2U AS=28.56P AD=15.3P PS=26U PD=13.2U
* device instance $2 r0 *1 10.1,44.8 PMOS
M$2 VDD A \$3 VDD PMOS L=1U W=10.2U AS=15.3P AD=15.3P PS=13.2U PD=13.2U
* device instance $3 r0 *1 14.1,44.8 PMOS
M$3 Y \$3 VDD VDD PMOS L=1U W=10.2U AS=15.3P AD=15.3P PS=13.2U PD=13.2U
* device instance $4 r0 *1 18.1,44.8 PMOS
M$4 VDD \$3 Y VDD PMOS L=1U W=10.2U AS=15.3P AD=15.3P PS=13.2U PD=13.2U
* device instance $5 r0 *1 22.1,44.8 PMOS
M$5 Y \$3 VDD VDD PMOS L=1U W=10.2U AS=15.3P AD=15.3P PS=13.2U PD=13.2U
* device instance $6 r0 *1 26.1,44.8 PMOS
M$6 VDD \$3 Y VDD PMOS L=1U W=10.2U AS=15.3P AD=15.3P PS=13.2U PD=13.2U
* device instance $7 r0 *1 30.1,44.8 PMOS
M$7 Y \$3 VDD VDD PMOS L=1U W=10.2U AS=15.3P AD=28.56P PS=13.2U PD=26U
* device instance $8 r0 *1 6.1,6.8 NMOS
M$8 \$3 A GND GND NMOS L=1U W=3.4U AS=9.52P AD=5.1P PS=12.4U PD=6.4U
* device instance $9 r0 *1 10.1,6.8 NMOS
M$9 GND A \$3 GND NMOS L=1U W=3.4U AS=5.1P AD=5.1P PS=6.4U PD=6.4U
* device instance $10 r0 *1 14.1,6.8 NMOS
M$10 Y \$3 GND GND NMOS L=1U W=3.4U AS=5.1P AD=5.1P PS=6.4U PD=6.4U
* device instance $11 r0 *1 18.1,6.8 NMOS
M$11 GND \$3 Y GND NMOS L=1U W=3.4U AS=5.1P AD=5.1P PS=6.4U PD=6.4U
* device instance $12 r0 *1 22.1,6.8 NMOS
M$12 Y \$3 GND GND NMOS L=1U W=3.4U AS=5.1P AD=5.1P PS=6.4U PD=6.4U
* device instance $13 r0 *1 26.1,6.8 NMOS
M$13 GND \$3 Y GND NMOS L=1U W=3.4U AS=5.1P AD=5.1P PS=6.4U PD=6.4U
* device instance $14 r0 *1 30.1,6.8 NMOS
M$14 Y \$3 GND GND NMOS L=1U W=3.4U AS=5.1P AD=9.52P PS=6.4U PD=12.4U
.ENDS CLKBUF_X1

* ==== CLKBUF_X12 ====
* Created by KLayout

* cell CLKBUF_X12
* pin Y
* pin A
* pin VDD
* pin GND
.SUBCKT CLKBUF_X12 Y A VDD GND
* device instance $1 r0 *1 6.1,44.8 PMOS
M$1 \$4 A VDD VDD PMOS L=1U W=10.2U AS=28.56P AD=15.3P PS=26U PD=13.2U
* device instance $2 r0 *1 10.1,44.8 PMOS
M$2 VDD A \$4 VDD PMOS L=1U W=10.2U AS=15.3P AD=15.3P PS=13.2U PD=13.2U
* device instance $3 r0 *1 14.1,44.8 PMOS
M$3 \$4 A VDD VDD PMOS L=1U W=10.2U AS=15.3P AD=15.3P PS=13.2U PD=13.2U
* device instance $4 r0 *1 18.1,44.8 PMOS
M$4 VDD A \$4 VDD PMOS L=1U W=10.2U AS=15.3P AD=15.3P PS=13.2U PD=13.2U
* device instance $5 r0 *1 22.1,44.8 PMOS
M$5 \$4 A VDD VDD PMOS L=1U W=10.2U AS=15.3P AD=15.3P PS=13.2U PD=13.2U
* device instance $6 r0 *1 26.1,44.8 PMOS
M$6 VDD A \$4 VDD PMOS L=1U W=10.2U AS=15.3P AD=15.3P PS=13.2U PD=13.2U
* device instance $7 r0 *1 30.1,44.8 PMOS
M$7 \$4 A VDD VDD PMOS L=1U W=10.2U AS=15.3P AD=15.3P PS=13.2U PD=13.2U
* device instance $8 r0 *1 34.1,44.8 PMOS
M$8 VDD A \$4 VDD PMOS L=1U W=10.2U AS=15.3P AD=15.3P PS=13.2U PD=13.2U
* device instance $9 r0 *1 38.1,44.8 PMOS
M$9 \$4 A VDD VDD PMOS L=1U W=10.2U AS=15.3P AD=15.3P PS=13.2U PD=13.2U
* device instance $10 r0 *1 42.1,44.8 PMOS
M$10 VDD A \$4 VDD PMOS L=1U W=10.2U AS=15.3P AD=15.3P PS=13.2U PD=13.2U
* device instance $11 r0 *1 46.1,44.8 PMOS
M$11 Y \$4 VDD VDD PMOS L=1U W=10.2U AS=15.3P AD=15.3P PS=13.2U PD=13.2U
* device instance $12 r0 *1 50.1,44.8 PMOS
M$12 VDD \$4 Y VDD PMOS L=1U W=10.2U AS=15.3P AD=15.3P PS=13.2U PD=13.2U
* device instance $13 r0 *1 54.1,44.8 PMOS
M$13 Y \$4 VDD VDD PMOS L=1U W=10.2U AS=15.3P AD=15.3P PS=13.2U PD=13.2U
* device instance $14 r0 *1 58.1,44.8 PMOS
M$14 VDD \$4 Y VDD PMOS L=1U W=10.2U AS=15.3P AD=15.3P PS=13.2U PD=13.2U
* device instance $15 r0 *1 62.1,44.8 PMOS
M$15 Y \$4 VDD VDD PMOS L=1U W=10.2U AS=15.3P AD=15.3P PS=13.2U PD=13.2U
* device instance $16 r0 *1 66.1,44.8 PMOS
M$16 VDD \$4 Y VDD PMOS L=1U W=10.2U AS=15.3P AD=15.3P PS=13.2U PD=13.2U
* device instance $17 r0 *1 70.1,44.8 PMOS
M$17 Y \$4 VDD VDD PMOS L=1U W=10.2U AS=15.3P AD=15.3P PS=13.2U PD=13.2U
* device instance $18 r0 *1 74.1,44.8 PMOS
M$18 VDD \$4 Y VDD PMOS L=1U W=10.2U AS=15.3P AD=15.3P PS=13.2U PD=13.2U
* device instance $19 r0 *1 78.1,44.8 PMOS
M$19 Y \$4 VDD VDD PMOS L=1U W=10.2U AS=15.3P AD=15.3P PS=13.2U PD=13.2U
* device instance $20 r0 *1 82.1,44.8 PMOS
M$20 VDD \$4 Y VDD PMOS L=1U W=10.2U AS=15.3P AD=15.3P PS=13.2U PD=13.2U
* device instance $21 r0 *1 86.1,44.8 PMOS
M$21 Y \$4 VDD VDD PMOS L=1U W=10.2U AS=15.3P AD=15.3P PS=13.2U PD=13.2U
* device instance $22 r0 *1 90.1,44.8 PMOS
M$22 VDD \$4 Y VDD PMOS L=1U W=10.2U AS=15.3P AD=15.3P PS=13.2U PD=13.2U
* device instance $23 r0 *1 94.1,44.8 PMOS
M$23 Y \$4 VDD VDD PMOS L=1U W=10.2U AS=15.3P AD=15.3P PS=13.2U PD=13.2U
* device instance $24 r0 *1 98.1,44.8 PMOS
M$24 VDD \$4 Y VDD PMOS L=1U W=10.2U AS=15.3P AD=15.3P PS=13.2U PD=13.2U
* device instance $25 r0 *1 102.1,44.8 PMOS
M$25 Y \$4 VDD VDD PMOS L=1U W=10.2U AS=15.3P AD=15.3P PS=13.2U PD=13.2U
* device instance $26 r0 *1 106.1,44.8 PMOS
M$26 VDD \$4 Y VDD PMOS L=1U W=10.2U AS=15.3P AD=15.3P PS=13.2U PD=13.2U
* device instance $27 r0 *1 110.1,44.8 PMOS
M$27 Y \$4 VDD VDD PMOS L=1U W=10.2U AS=15.3P AD=15.3P PS=13.2U PD=13.2U
* device instance $28 r0 *1 114.1,44.8 PMOS
M$28 VDD \$4 Y VDD PMOS L=1U W=10.2U AS=15.3P AD=15.3P PS=13.2U PD=13.2U
* device instance $29 r0 *1 118.1,44.8 PMOS
M$29 Y \$4 VDD VDD PMOS L=1U W=10.2U AS=15.3P AD=15.3P PS=13.2U PD=13.2U
* device instance $30 r0 *1 122.1,44.8 PMOS
M$30 VDD \$4 Y VDD PMOS L=1U W=10.2U AS=15.3P AD=15.3P PS=13.2U PD=13.2U
* device instance $31 r0 *1 126.1,44.8 PMOS
M$31 Y \$4 VDD VDD PMOS L=1U W=10.2U AS=15.3P AD=15.3P PS=13.2U PD=13.2U
* device instance $32 r0 *1 130.1,44.8 PMOS
M$32 VDD \$4 Y VDD PMOS L=1U W=10.2U AS=15.3P AD=15.3P PS=13.2U PD=13.2U
* device instance $33 r0 *1 134.1,44.8 PMOS
M$33 Y \$4 VDD VDD PMOS L=1U W=10.2U AS=15.3P AD=15.3P PS=13.2U PD=13.2U
* device instance $34 r0 *1 138.1,44.8 PMOS
M$34 VDD \$4 Y VDD PMOS L=1U W=10.2U AS=15.3P AD=15.3P PS=13.2U PD=13.2U
* device instance $35 r0 *1 142.1,44.8 PMOS
M$35 Y \$4 VDD VDD PMOS L=1U W=10.2U AS=15.3P AD=15.3P PS=13.2U PD=13.2U
* device instance $36 r0 *1 146.1,44.8 PMOS
M$36 VDD \$4 Y VDD PMOS L=1U W=10.2U AS=15.3P AD=15.3P PS=13.2U PD=13.2U
* device instance $37 r0 *1 150.1,44.8 PMOS
M$37 Y \$4 VDD VDD PMOS L=1U W=10.2U AS=15.3P AD=15.3P PS=13.2U PD=13.2U
* device instance $38 r0 *1 154.1,44.8 PMOS
M$38 VDD \$4 Y VDD PMOS L=1U W=10.2U AS=15.3P AD=15.3P PS=13.2U PD=13.2U
* device instance $39 r0 *1 158.1,44.8 PMOS
M$39 Y \$4 VDD VDD PMOS L=1U W=10.2U AS=15.3P AD=15.3P PS=13.2U PD=13.2U
* device instance $40 r0 *1 162.1,44.8 PMOS
M$40 VDD \$4 Y VDD PMOS L=1U W=10.2U AS=15.3P AD=15.3P PS=13.2U PD=13.2U
* device instance $41 r0 *1 166.1,44.8 PMOS
M$41 Y \$4 VDD VDD PMOS L=1U W=10.2U AS=15.3P AD=15.3P PS=13.2U PD=13.2U
* device instance $42 r0 *1 170.1,44.8 PMOS
M$42 VDD \$4 Y VDD PMOS L=1U W=10.2U AS=15.3P AD=15.3P PS=13.2U PD=13.2U
* device instance $43 r0 *1 174.1,44.8 PMOS
M$43 Y \$4 VDD VDD PMOS L=1U W=10.2U AS=15.3P AD=15.3P PS=13.2U PD=13.2U
* device instance $44 r0 *1 178.1,44.8 PMOS
M$44 VDD \$4 Y VDD PMOS L=1U W=10.2U AS=15.3P AD=15.3P PS=13.2U PD=13.2U
* device instance $45 r0 *1 182.1,44.8 PMOS
M$45 Y \$4 VDD VDD PMOS L=1U W=10.2U AS=15.3P AD=15.3P PS=13.2U PD=13.2U
* device instance $46 r0 *1 186.1,44.8 PMOS
M$46 VDD \$4 Y VDD PMOS L=1U W=10.2U AS=15.3P AD=15.3P PS=13.2U PD=13.2U
* device instance $47 r0 *1 190.1,44.8 PMOS
M$47 Y \$4 VDD VDD PMOS L=1U W=10.2U AS=15.3P AD=15.3P PS=13.2U PD=13.2U
* device instance $48 r0 *1 194.1,44.8 PMOS
M$48 VDD \$4 Y VDD PMOS L=1U W=10.2U AS=15.3P AD=15.3P PS=13.2U PD=13.2U
* device instance $49 r0 *1 198.1,44.8 PMOS
M$49 Y \$4 VDD VDD PMOS L=1U W=10.2U AS=15.3P AD=15.3P PS=13.2U PD=13.2U
* device instance $50 r0 *1 202.1,44.8 PMOS
M$50 VDD \$4 Y VDD PMOS L=1U W=10.2U AS=15.3P AD=15.3P PS=13.2U PD=13.2U
* device instance $51 r0 *1 206.1,44.8 PMOS
M$51 Y \$4 VDD VDD PMOS L=1U W=10.2U AS=15.3P AD=15.3P PS=13.2U PD=13.2U
* device instance $52 r0 *1 210.1,44.8 PMOS
M$52 VDD \$4 Y VDD PMOS L=1U W=10.2U AS=15.3P AD=15.3P PS=13.2U PD=13.2U
* device instance $53 r0 *1 214.1,44.8 PMOS
M$53 Y \$4 VDD VDD PMOS L=1U W=10.2U AS=15.3P AD=15.3P PS=13.2U PD=13.2U
* device instance $54 r0 *1 218.1,44.8 PMOS
M$54 VDD \$4 Y VDD PMOS L=1U W=10.2U AS=15.3P AD=15.3P PS=13.2U PD=13.2U
* device instance $55 r0 *1 222.1,44.8 PMOS
M$55 Y \$4 VDD VDD PMOS L=1U W=10.2U AS=15.3P AD=15.3P PS=13.2U PD=13.2U
* device instance $56 r0 *1 226.1,44.8 PMOS
M$56 VDD \$4 Y VDD PMOS L=1U W=10.2U AS=15.3P AD=15.3P PS=13.2U PD=13.2U
* device instance $57 r0 *1 230.1,44.8 PMOS
M$57 Y \$4 VDD VDD PMOS L=1U W=10.2U AS=15.3P AD=15.3P PS=13.2U PD=13.2U
* device instance $58 r0 *1 234.1,44.8 PMOS
M$58 VDD \$4 Y VDD PMOS L=1U W=10.2U AS=15.3P AD=15.3P PS=13.2U PD=13.2U
* device instance $59 r0 *1 238.1,44.8 PMOS
M$59 Y \$4 VDD VDD PMOS L=1U W=10.2U AS=15.3P AD=15.3P PS=13.2U PD=13.2U
* device instance $60 r0 *1 242.1,44.8 PMOS
M$60 VDD \$4 Y VDD PMOS L=1U W=10.2U AS=15.3P AD=15.3P PS=13.2U PD=13.2U
* device instance $61 r0 *1 246.1,44.8 PMOS
M$61 Y \$4 VDD VDD PMOS L=1U W=10.2U AS=15.3P AD=15.3P PS=13.2U PD=13.2U
* device instance $62 r0 *1 250.1,44.8 PMOS
M$62 VDD \$4 Y VDD PMOS L=1U W=10.2U AS=15.3P AD=15.3P PS=13.2U PD=13.2U
* device instance $63 r0 *1 254.1,44.8 PMOS
M$63 Y \$4 VDD VDD PMOS L=1U W=10.2U AS=15.3P AD=15.3P PS=13.2U PD=13.2U
* device instance $64 r0 *1 258.1,44.8 PMOS
M$64 VDD \$4 Y VDD PMOS L=1U W=10.2U AS=15.3P AD=15.3P PS=13.2U PD=13.2U
* device instance $65 r0 *1 262.1,44.8 PMOS
M$65 Y \$4 VDD VDD PMOS L=1U W=10.2U AS=15.3P AD=15.3P PS=13.2U PD=13.2U
* device instance $66 r0 *1 266.1,44.8 PMOS
M$66 VDD \$4 Y VDD PMOS L=1U W=10.2U AS=15.3P AD=15.3P PS=13.2U PD=13.2U
* device instance $67 r0 *1 270.1,44.8 PMOS
M$67 Y \$4 VDD VDD PMOS L=1U W=10.2U AS=15.3P AD=15.3P PS=13.2U PD=13.2U
* device instance $68 r0 *1 274.1,44.8 PMOS
M$68 VDD \$4 Y VDD PMOS L=1U W=10.2U AS=15.3P AD=15.3P PS=13.2U PD=13.2U
* device instance $69 r0 *1 278.1,44.8 PMOS
M$69 Y \$4 VDD VDD PMOS L=1U W=10.2U AS=15.3P AD=15.3P PS=13.2U PD=13.2U
* device instance $70 r0 *1 282.1,44.8 PMOS
M$70 VDD \$4 Y VDD PMOS L=1U W=10.2U AS=15.3P AD=28.56P PS=13.2U PD=26U
* device instance $71 r0 *1 6.1,6.8 NMOS
M$71 \$4 A GND GND NMOS L=1U W=3.4U AS=9.52P AD=5.1P PS=12.4U PD=6.4U
* device instance $72 r0 *1 10.1,6.8 NMOS
M$72 GND A \$4 GND NMOS L=1U W=3.4U AS=5.1P AD=5.1P PS=6.4U PD=6.4U
* device instance $73 r0 *1 14.1,6.8 NMOS
M$73 \$4 A GND GND NMOS L=1U W=3.4U AS=5.1P AD=5.1P PS=6.4U PD=6.4U
* device instance $74 r0 *1 18.1,6.8 NMOS
M$74 GND A \$4 GND NMOS L=1U W=3.4U AS=5.1P AD=5.1P PS=6.4U PD=6.4U
* device instance $75 r0 *1 22.1,6.8 NMOS
M$75 \$4 A GND GND NMOS L=1U W=3.4U AS=5.1P AD=5.1P PS=6.4U PD=6.4U
* device instance $76 r0 *1 26.1,6.8 NMOS
M$76 GND A \$4 GND NMOS L=1U W=3.4U AS=5.1P AD=5.1P PS=6.4U PD=6.4U
* device instance $77 r0 *1 30.1,6.8 NMOS
M$77 \$4 A GND GND NMOS L=1U W=3.4U AS=5.1P AD=5.1P PS=6.4U PD=6.4U
* device instance $78 r0 *1 34.1,6.8 NMOS
M$78 GND A \$4 GND NMOS L=1U W=3.4U AS=5.1P AD=5.1P PS=6.4U PD=6.4U
* device instance $79 r0 *1 38.1,6.8 NMOS
M$79 \$4 A GND GND NMOS L=1U W=3.4U AS=5.1P AD=5.1P PS=6.4U PD=6.4U
* device instance $80 r0 *1 42.1,6.8 NMOS
M$80 GND A \$4 GND NMOS L=1U W=3.4U AS=5.1P AD=5.1P PS=6.4U PD=6.4U
* device instance $81 r0 *1 46.1,6.8 NMOS
M$81 Y \$4 GND GND NMOS L=1U W=3.4U AS=5.1P AD=5.1P PS=6.4U PD=6.4U
* device instance $82 r0 *1 50.1,6.8 NMOS
M$82 GND \$4 Y GND NMOS L=1U W=3.4U AS=5.1P AD=5.1P PS=6.4U PD=6.4U
* device instance $83 r0 *1 54.1,6.8 NMOS
M$83 Y \$4 GND GND NMOS L=1U W=3.4U AS=5.1P AD=5.1P PS=6.4U PD=6.4U
* device instance $84 r0 *1 58.1,6.8 NMOS
M$84 GND \$4 Y GND NMOS L=1U W=3.4U AS=5.1P AD=5.1P PS=6.4U PD=6.4U
* device instance $85 r0 *1 62.1,6.8 NMOS
M$85 Y \$4 GND GND NMOS L=1U W=3.4U AS=5.1P AD=5.1P PS=6.4U PD=6.4U
* device instance $86 r0 *1 66.1,6.8 NMOS
M$86 GND \$4 Y GND NMOS L=1U W=3.4U AS=5.1P AD=5.1P PS=6.4U PD=6.4U
* device instance $87 r0 *1 70.1,6.8 NMOS
M$87 Y \$4 GND GND NMOS L=1U W=3.4U AS=5.1P AD=5.1P PS=6.4U PD=6.4U
* device instance $88 r0 *1 74.1,6.8 NMOS
M$88 GND \$4 Y GND NMOS L=1U W=3.4U AS=5.1P AD=5.1P PS=6.4U PD=6.4U
* device instance $89 r0 *1 78.1,6.8 NMOS
M$89 Y \$4 GND GND NMOS L=1U W=3.4U AS=5.1P AD=5.1P PS=6.4U PD=6.4U
* device instance $90 r0 *1 82.1,6.8 NMOS
M$90 GND \$4 Y GND NMOS L=1U W=3.4U AS=5.1P AD=5.1P PS=6.4U PD=6.4U
* device instance $91 r0 *1 86.1,6.8 NMOS
M$91 Y \$4 GND GND NMOS L=1U W=3.4U AS=5.1P AD=5.1P PS=6.4U PD=6.4U
* device instance $92 r0 *1 90.1,6.8 NMOS
M$92 GND \$4 Y GND NMOS L=1U W=3.4U AS=5.1P AD=5.1P PS=6.4U PD=6.4U
* device instance $93 r0 *1 94.1,6.8 NMOS
M$93 Y \$4 GND GND NMOS L=1U W=3.4U AS=5.1P AD=5.1P PS=6.4U PD=6.4U
* device instance $94 r0 *1 98.1,6.8 NMOS
M$94 GND \$4 Y GND NMOS L=1U W=3.4U AS=5.1P AD=5.1P PS=6.4U PD=6.4U
* device instance $95 r0 *1 102.1,6.8 NMOS
M$95 Y \$4 GND GND NMOS L=1U W=3.4U AS=5.1P AD=5.1P PS=6.4U PD=6.4U
* device instance $96 r0 *1 106.1,6.8 NMOS
M$96 GND \$4 Y GND NMOS L=1U W=3.4U AS=5.1P AD=5.1P PS=6.4U PD=6.4U
* device instance $97 r0 *1 110.1,6.8 NMOS
M$97 Y \$4 GND GND NMOS L=1U W=3.4U AS=5.1P AD=5.1P PS=6.4U PD=6.4U
* device instance $98 r0 *1 114.1,6.8 NMOS
M$98 GND \$4 Y GND NMOS L=1U W=3.4U AS=5.1P AD=5.1P PS=6.4U PD=6.4U
* device instance $99 r0 *1 118.1,6.8 NMOS
M$99 Y \$4 GND GND NMOS L=1U W=3.4U AS=5.1P AD=5.1P PS=6.4U PD=6.4U
* device instance $100 r0 *1 122.1,6.8 NMOS
M$100 GND \$4 Y GND NMOS L=1U W=3.4U AS=5.1P AD=5.1P PS=6.4U PD=6.4U
* device instance $101 r0 *1 126.1,6.8 NMOS
M$101 Y \$4 GND GND NMOS L=1U W=3.4U AS=5.1P AD=5.1P PS=6.4U PD=6.4U
* device instance $102 r0 *1 130.1,6.8 NMOS
M$102 GND \$4 Y GND NMOS L=1U W=3.4U AS=5.1P AD=5.1P PS=6.4U PD=6.4U
* device instance $103 r0 *1 134.1,6.8 NMOS
M$103 Y \$4 GND GND NMOS L=1U W=3.4U AS=5.1P AD=5.1P PS=6.4U PD=6.4U
* device instance $104 r0 *1 138.1,6.8 NMOS
M$104 GND \$4 Y GND NMOS L=1U W=3.4U AS=5.1P AD=5.1P PS=6.4U PD=6.4U
* device instance $105 r0 *1 142.1,6.8 NMOS
M$105 Y \$4 GND GND NMOS L=1U W=3.4U AS=5.1P AD=5.1P PS=6.4U PD=6.4U
* device instance $106 r0 *1 146.1,6.8 NMOS
M$106 GND \$4 Y GND NMOS L=1U W=3.4U AS=5.1P AD=5.1P PS=6.4U PD=6.4U
* device instance $107 r0 *1 150.1,6.8 NMOS
M$107 Y \$4 GND GND NMOS L=1U W=3.4U AS=5.1P AD=5.1P PS=6.4U PD=6.4U
* device instance $108 r0 *1 154.1,6.8 NMOS
M$108 GND \$4 Y GND NMOS L=1U W=3.4U AS=5.1P AD=5.1P PS=6.4U PD=6.4U
* device instance $109 r0 *1 158.1,6.8 NMOS
M$109 Y \$4 GND GND NMOS L=1U W=3.4U AS=5.1P AD=5.1P PS=6.4U PD=6.4U
* device instance $110 r0 *1 162.1,6.8 NMOS
M$110 GND \$4 Y GND NMOS L=1U W=3.4U AS=5.1P AD=5.1P PS=6.4U PD=6.4U
* device instance $111 r0 *1 166.1,6.8 NMOS
M$111 Y \$4 GND GND NMOS L=1U W=3.4U AS=5.1P AD=5.1P PS=6.4U PD=6.4U
* device instance $112 r0 *1 170.1,6.8 NMOS
M$112 GND \$4 Y GND NMOS L=1U W=3.4U AS=5.1P AD=5.1P PS=6.4U PD=6.4U
* device instance $113 r0 *1 174.1,6.8 NMOS
M$113 Y \$4 GND GND NMOS L=1U W=3.4U AS=5.1P AD=5.1P PS=6.4U PD=6.4U
* device instance $114 r0 *1 178.1,6.8 NMOS
M$114 GND \$4 Y GND NMOS L=1U W=3.4U AS=5.1P AD=5.1P PS=6.4U PD=6.4U
* device instance $115 r0 *1 182.1,6.8 NMOS
M$115 Y \$4 GND GND NMOS L=1U W=3.4U AS=5.1P AD=5.1P PS=6.4U PD=6.4U
* device instance $116 r0 *1 186.1,6.8 NMOS
M$116 GND \$4 Y GND NMOS L=1U W=3.4U AS=5.1P AD=5.1P PS=6.4U PD=6.4U
* device instance $117 r0 *1 190.1,6.8 NMOS
M$117 Y \$4 GND GND NMOS L=1U W=3.4U AS=5.1P AD=5.1P PS=6.4U PD=6.4U
* device instance $118 r0 *1 194.1,6.8 NMOS
M$118 GND \$4 Y GND NMOS L=1U W=3.4U AS=5.1P AD=5.1P PS=6.4U PD=6.4U
* device instance $119 r0 *1 198.1,6.8 NMOS
M$119 Y \$4 GND GND NMOS L=1U W=3.4U AS=5.1P AD=5.1P PS=6.4U PD=6.4U
* device instance $120 r0 *1 202.1,6.8 NMOS
M$120 GND \$4 Y GND NMOS L=1U W=3.4U AS=5.1P AD=5.1P PS=6.4U PD=6.4U
* device instance $121 r0 *1 206.1,6.8 NMOS
M$121 Y \$4 GND GND NMOS L=1U W=3.4U AS=5.1P AD=5.1P PS=6.4U PD=6.4U
* device instance $122 r0 *1 210.1,6.8 NMOS
M$122 GND \$4 Y GND NMOS L=1U W=3.4U AS=5.1P AD=5.1P PS=6.4U PD=6.4U
* device instance $123 r0 *1 214.1,6.8 NMOS
M$123 Y \$4 GND GND NMOS L=1U W=3.4U AS=5.1P AD=5.1P PS=6.4U PD=6.4U
* device instance $124 r0 *1 218.1,6.8 NMOS
M$124 GND \$4 Y GND NMOS L=1U W=3.4U AS=5.1P AD=5.1P PS=6.4U PD=6.4U
* device instance $125 r0 *1 222.1,6.8 NMOS
M$125 Y \$4 GND GND NMOS L=1U W=3.4U AS=5.1P AD=5.1P PS=6.4U PD=6.4U
* device instance $126 r0 *1 226.1,6.8 NMOS
M$126 GND \$4 Y GND NMOS L=1U W=3.4U AS=5.1P AD=5.1P PS=6.4U PD=6.4U
* device instance $127 r0 *1 230.1,6.8 NMOS
M$127 Y \$4 GND GND NMOS L=1U W=3.4U AS=5.1P AD=5.1P PS=6.4U PD=6.4U
* device instance $128 r0 *1 234.1,6.8 NMOS
M$128 GND \$4 Y GND NMOS L=1U W=3.4U AS=5.1P AD=5.1P PS=6.4U PD=6.4U
* device instance $129 r0 *1 238.1,6.8 NMOS
M$129 Y \$4 GND GND NMOS L=1U W=3.4U AS=5.1P AD=5.1P PS=6.4U PD=6.4U
* device instance $130 r0 *1 242.1,6.8 NMOS
M$130 GND \$4 Y GND NMOS L=1U W=3.4U AS=5.1P AD=5.1P PS=6.4U PD=6.4U
* device instance $131 r0 *1 246.1,6.8 NMOS
M$131 Y \$4 GND GND NMOS L=1U W=3.4U AS=5.1P AD=5.1P PS=6.4U PD=6.4U
* device instance $132 r0 *1 250.1,6.8 NMOS
M$132 GND \$4 Y GND NMOS L=1U W=3.4U AS=5.1P AD=5.1P PS=6.4U PD=6.4U
* device instance $133 r0 *1 254.1,6.8 NMOS
M$133 Y \$4 GND GND NMOS L=1U W=3.4U AS=5.1P AD=5.1P PS=6.4U PD=6.4U
* device instance $134 r0 *1 258.1,6.8 NMOS
M$134 GND \$4 Y GND NMOS L=1U W=3.4U AS=5.1P AD=5.1P PS=6.4U PD=6.4U
* device instance $135 r0 *1 262.1,6.8 NMOS
M$135 Y \$4 GND GND NMOS L=1U W=3.4U AS=5.1P AD=5.1P PS=6.4U PD=6.4U
* device instance $136 r0 *1 266.1,6.8 NMOS
M$136 GND \$4 Y GND NMOS L=1U W=3.4U AS=5.1P AD=5.1P PS=6.4U PD=6.4U
* device instance $137 r0 *1 270.1,6.8 NMOS
M$137 Y \$4 GND GND NMOS L=1U W=3.4U AS=5.1P AD=5.1P PS=6.4U PD=6.4U
* device instance $138 r0 *1 274.1,6.8 NMOS
M$138 GND \$4 Y GND NMOS L=1U W=3.4U AS=5.1P AD=5.1P PS=6.4U PD=6.4U
* device instance $139 r0 *1 278.1,6.8 NMOS
M$139 Y \$4 GND GND NMOS L=1U W=3.4U AS=5.1P AD=5.1P PS=6.4U PD=6.4U
* device instance $140 r0 *1 282.1,6.8 NMOS
M$140 GND \$4 Y GND NMOS L=1U W=3.4U AS=5.1P AD=9.52P PS=6.4U PD=12.4U
.ENDS CLKBUF_X12

* ==== CLKBUF_X16 ====
* Created by KLayout

* cell CLKBUF_X16
* pin Y
* pin A
* pin VDD
* pin GND
.SUBCKT CLKBUF_X16 Y A VDD GND
* device instance $1 r0 *1 6.1,44.8 PMOS
M$1 \$4 A VDD VDD PMOS L=1U W=10.2U AS=28.56P AD=15.3P PS=26U PD=13.2U
* device instance $2 r0 *1 10.1,44.8 PMOS
M$2 VDD A \$4 VDD PMOS L=1U W=10.2U AS=15.3P AD=15.3P PS=13.2U PD=13.2U
* device instance $3 r0 *1 14.1,44.8 PMOS
M$3 \$4 A VDD VDD PMOS L=1U W=10.2U AS=15.3P AD=15.3P PS=13.2U PD=13.2U
* device instance $4 r0 *1 18.1,44.8 PMOS
M$4 VDD A \$4 VDD PMOS L=1U W=10.2U AS=15.3P AD=15.3P PS=13.2U PD=13.2U
* device instance $5 r0 *1 22.1,44.8 PMOS
M$5 \$4 A VDD VDD PMOS L=1U W=10.2U AS=15.3P AD=15.3P PS=13.2U PD=13.2U
* device instance $6 r0 *1 26.1,44.8 PMOS
M$6 VDD A \$4 VDD PMOS L=1U W=10.2U AS=15.3P AD=15.3P PS=13.2U PD=13.2U
* device instance $7 r0 *1 30.1,44.8 PMOS
M$7 \$4 A VDD VDD PMOS L=1U W=10.2U AS=15.3P AD=15.3P PS=13.2U PD=13.2U
* device instance $8 r0 *1 34.1,44.8 PMOS
M$8 VDD A \$4 VDD PMOS L=1U W=10.2U AS=15.3P AD=15.3P PS=13.2U PD=13.2U
* device instance $9 r0 *1 38.1,44.8 PMOS
M$9 \$4 A VDD VDD PMOS L=1U W=10.2U AS=15.3P AD=15.3P PS=13.2U PD=13.2U
* device instance $10 r0 *1 42.1,44.8 PMOS
M$10 VDD A \$4 VDD PMOS L=1U W=10.2U AS=15.3P AD=15.3P PS=13.2U PD=13.2U
* device instance $11 r0 *1 46.1,44.8 PMOS
M$11 \$4 A VDD VDD PMOS L=1U W=10.2U AS=15.3P AD=15.3P PS=13.2U PD=13.2U
* device instance $12 r0 *1 50.1,44.8 PMOS
M$12 VDD A \$4 VDD PMOS L=1U W=10.2U AS=15.3P AD=15.3P PS=13.2U PD=13.2U
* device instance $13 r0 *1 54.1,44.8 PMOS
M$13 Y \$4 VDD VDD PMOS L=1U W=10.2U AS=15.3P AD=15.3P PS=13.2U PD=13.2U
* device instance $14 r0 *1 58.1,44.8 PMOS
M$14 VDD \$4 Y VDD PMOS L=1U W=10.2U AS=15.3P AD=15.3P PS=13.2U PD=13.2U
* device instance $15 r0 *1 62.1,44.8 PMOS
M$15 Y \$4 VDD VDD PMOS L=1U W=10.2U AS=15.3P AD=15.3P PS=13.2U PD=13.2U
* device instance $16 r0 *1 66.1,44.8 PMOS
M$16 VDD \$4 Y VDD PMOS L=1U W=10.2U AS=15.3P AD=15.3P PS=13.2U PD=13.2U
* device instance $17 r0 *1 70.1,44.8 PMOS
M$17 Y \$4 VDD VDD PMOS L=1U W=10.2U AS=15.3P AD=15.3P PS=13.2U PD=13.2U
* device instance $18 r0 *1 74.1,44.8 PMOS
M$18 VDD \$4 Y VDD PMOS L=1U W=10.2U AS=15.3P AD=15.3P PS=13.2U PD=13.2U
* device instance $19 r0 *1 78.1,44.8 PMOS
M$19 Y \$4 VDD VDD PMOS L=1U W=10.2U AS=15.3P AD=15.3P PS=13.2U PD=13.2U
* device instance $20 r0 *1 82.1,44.8 PMOS
M$20 VDD \$4 Y VDD PMOS L=1U W=10.2U AS=15.3P AD=15.3P PS=13.2U PD=13.2U
* device instance $21 r0 *1 86.1,44.8 PMOS
M$21 Y \$4 VDD VDD PMOS L=1U W=10.2U AS=15.3P AD=15.3P PS=13.2U PD=13.2U
* device instance $22 r0 *1 90.1,44.8 PMOS
M$22 VDD \$4 Y VDD PMOS L=1U W=10.2U AS=15.3P AD=15.3P PS=13.2U PD=13.2U
* device instance $23 r0 *1 94.1,44.8 PMOS
M$23 Y \$4 VDD VDD PMOS L=1U W=10.2U AS=15.3P AD=15.3P PS=13.2U PD=13.2U
* device instance $24 r0 *1 98.1,44.8 PMOS
M$24 VDD \$4 Y VDD PMOS L=1U W=10.2U AS=15.3P AD=15.3P PS=13.2U PD=13.2U
* device instance $25 r0 *1 102.1,44.8 PMOS
M$25 Y \$4 VDD VDD PMOS L=1U W=10.2U AS=15.3P AD=15.3P PS=13.2U PD=13.2U
* device instance $26 r0 *1 106.1,44.8 PMOS
M$26 VDD \$4 Y VDD PMOS L=1U W=10.2U AS=15.3P AD=15.3P PS=13.2U PD=13.2U
* device instance $27 r0 *1 110.1,44.8 PMOS
M$27 Y \$4 VDD VDD PMOS L=1U W=10.2U AS=15.3P AD=15.3P PS=13.2U PD=13.2U
* device instance $28 r0 *1 114.1,44.8 PMOS
M$28 VDD \$4 Y VDD PMOS L=1U W=10.2U AS=15.3P AD=15.3P PS=13.2U PD=13.2U
* device instance $29 r0 *1 118.1,44.8 PMOS
M$29 Y \$4 VDD VDD PMOS L=1U W=10.2U AS=15.3P AD=15.3P PS=13.2U PD=13.2U
* device instance $30 r0 *1 122.1,44.8 PMOS
M$30 VDD \$4 Y VDD PMOS L=1U W=10.2U AS=15.3P AD=15.3P PS=13.2U PD=13.2U
* device instance $31 r0 *1 126.1,44.8 PMOS
M$31 Y \$4 VDD VDD PMOS L=1U W=10.2U AS=15.3P AD=15.3P PS=13.2U PD=13.2U
* device instance $32 r0 *1 130.1,44.8 PMOS
M$32 VDD \$4 Y VDD PMOS L=1U W=10.2U AS=15.3P AD=15.3P PS=13.2U PD=13.2U
* device instance $33 r0 *1 134.1,44.8 PMOS
M$33 Y \$4 VDD VDD PMOS L=1U W=10.2U AS=15.3P AD=15.3P PS=13.2U PD=13.2U
* device instance $34 r0 *1 138.1,44.8 PMOS
M$34 VDD \$4 Y VDD PMOS L=1U W=10.2U AS=15.3P AD=15.3P PS=13.2U PD=13.2U
* device instance $35 r0 *1 142.1,44.8 PMOS
M$35 Y \$4 VDD VDD PMOS L=1U W=10.2U AS=15.3P AD=15.3P PS=13.2U PD=13.2U
* device instance $36 r0 *1 146.1,44.8 PMOS
M$36 VDD \$4 Y VDD PMOS L=1U W=10.2U AS=15.3P AD=15.3P PS=13.2U PD=13.2U
* device instance $37 r0 *1 150.1,44.8 PMOS
M$37 Y \$4 VDD VDD PMOS L=1U W=10.2U AS=15.3P AD=15.3P PS=13.2U PD=13.2U
* device instance $38 r0 *1 154.1,44.8 PMOS
M$38 VDD \$4 Y VDD PMOS L=1U W=10.2U AS=15.3P AD=15.3P PS=13.2U PD=13.2U
* device instance $39 r0 *1 158.1,44.8 PMOS
M$39 Y \$4 VDD VDD PMOS L=1U W=10.2U AS=15.3P AD=15.3P PS=13.2U PD=13.2U
* device instance $40 r0 *1 162.1,44.8 PMOS
M$40 VDD \$4 Y VDD PMOS L=1U W=10.2U AS=15.3P AD=15.3P PS=13.2U PD=13.2U
* device instance $41 r0 *1 166.1,44.8 PMOS
M$41 Y \$4 VDD VDD PMOS L=1U W=10.2U AS=15.3P AD=15.3P PS=13.2U PD=13.2U
* device instance $42 r0 *1 170.1,44.8 PMOS
M$42 VDD \$4 Y VDD PMOS L=1U W=10.2U AS=15.3P AD=15.3P PS=13.2U PD=13.2U
* device instance $43 r0 *1 174.1,44.8 PMOS
M$43 Y \$4 VDD VDD PMOS L=1U W=10.2U AS=15.3P AD=15.3P PS=13.2U PD=13.2U
* device instance $44 r0 *1 178.1,44.8 PMOS
M$44 VDD \$4 Y VDD PMOS L=1U W=10.2U AS=15.3P AD=15.3P PS=13.2U PD=13.2U
* device instance $45 r0 *1 182.1,44.8 PMOS
M$45 Y \$4 VDD VDD PMOS L=1U W=10.2U AS=15.3P AD=15.3P PS=13.2U PD=13.2U
* device instance $46 r0 *1 186.1,44.8 PMOS
M$46 VDD \$4 Y VDD PMOS L=1U W=10.2U AS=15.3P AD=15.3P PS=13.2U PD=13.2U
* device instance $47 r0 *1 190.1,44.8 PMOS
M$47 Y \$4 VDD VDD PMOS L=1U W=10.2U AS=15.3P AD=15.3P PS=13.2U PD=13.2U
* device instance $48 r0 *1 194.1,44.8 PMOS
M$48 VDD \$4 Y VDD PMOS L=1U W=10.2U AS=15.3P AD=15.3P PS=13.2U PD=13.2U
* device instance $49 r0 *1 198.1,44.8 PMOS
M$49 Y \$4 VDD VDD PMOS L=1U W=10.2U AS=15.3P AD=15.3P PS=13.2U PD=13.2U
* device instance $50 r0 *1 202.1,44.8 PMOS
M$50 VDD \$4 Y VDD PMOS L=1U W=10.2U AS=15.3P AD=15.3P PS=13.2U PD=13.2U
* device instance $51 r0 *1 206.1,44.8 PMOS
M$51 Y \$4 VDD VDD PMOS L=1U W=10.2U AS=15.3P AD=15.3P PS=13.2U PD=13.2U
* device instance $52 r0 *1 210.1,44.8 PMOS
M$52 VDD \$4 Y VDD PMOS L=1U W=10.2U AS=15.3P AD=15.3P PS=13.2U PD=13.2U
* device instance $53 r0 *1 214.1,44.8 PMOS
M$53 Y \$4 VDD VDD PMOS L=1U W=10.2U AS=15.3P AD=15.3P PS=13.2U PD=13.2U
* device instance $54 r0 *1 218.1,44.8 PMOS
M$54 VDD \$4 Y VDD PMOS L=1U W=10.2U AS=15.3P AD=15.3P PS=13.2U PD=13.2U
* device instance $55 r0 *1 222.1,44.8 PMOS
M$55 Y \$4 VDD VDD PMOS L=1U W=10.2U AS=15.3P AD=15.3P PS=13.2U PD=13.2U
* device instance $56 r0 *1 226.1,44.8 PMOS
M$56 VDD \$4 Y VDD PMOS L=1U W=10.2U AS=15.3P AD=15.3P PS=13.2U PD=13.2U
* device instance $57 r0 *1 230.1,44.8 PMOS
M$57 Y \$4 VDD VDD PMOS L=1U W=10.2U AS=15.3P AD=15.3P PS=13.2U PD=13.2U
* device instance $58 r0 *1 234.1,44.8 PMOS
M$58 VDD \$4 Y VDD PMOS L=1U W=10.2U AS=15.3P AD=15.3P PS=13.2U PD=13.2U
* device instance $59 r0 *1 238.1,44.8 PMOS
M$59 Y \$4 VDD VDD PMOS L=1U W=10.2U AS=15.3P AD=15.3P PS=13.2U PD=13.2U
* device instance $60 r0 *1 242.1,44.8 PMOS
M$60 VDD \$4 Y VDD PMOS L=1U W=10.2U AS=15.3P AD=15.3P PS=13.2U PD=13.2U
* device instance $61 r0 *1 246.1,44.8 PMOS
M$61 Y \$4 VDD VDD PMOS L=1U W=10.2U AS=15.3P AD=15.3P PS=13.2U PD=13.2U
* device instance $62 r0 *1 250.1,44.8 PMOS
M$62 VDD \$4 Y VDD PMOS L=1U W=10.2U AS=15.3P AD=15.3P PS=13.2U PD=13.2U
* device instance $63 r0 *1 254.1,44.8 PMOS
M$63 Y \$4 VDD VDD PMOS L=1U W=10.2U AS=15.3P AD=15.3P PS=13.2U PD=13.2U
* device instance $64 r0 *1 258.1,44.8 PMOS
M$64 VDD \$4 Y VDD PMOS L=1U W=10.2U AS=15.3P AD=15.3P PS=13.2U PD=13.2U
* device instance $65 r0 *1 262.1,44.8 PMOS
M$65 Y \$4 VDD VDD PMOS L=1U W=10.2U AS=15.3P AD=15.3P PS=13.2U PD=13.2U
* device instance $66 r0 *1 266.1,44.8 PMOS
M$66 VDD \$4 Y VDD PMOS L=1U W=10.2U AS=15.3P AD=15.3P PS=13.2U PD=13.2U
* device instance $67 r0 *1 270.1,44.8 PMOS
M$67 Y \$4 VDD VDD PMOS L=1U W=10.2U AS=15.3P AD=15.3P PS=13.2U PD=13.2U
* device instance $68 r0 *1 274.1,44.8 PMOS
M$68 VDD \$4 Y VDD PMOS L=1U W=10.2U AS=15.3P AD=15.3P PS=13.2U PD=13.2U
* device instance $69 r0 *1 278.1,44.8 PMOS
M$69 Y \$4 VDD VDD PMOS L=1U W=10.2U AS=15.3P AD=15.3P PS=13.2U PD=13.2U
* device instance $70 r0 *1 282.1,44.8 PMOS
M$70 VDD \$4 Y VDD PMOS L=1U W=10.2U AS=15.3P AD=15.3P PS=13.2U PD=13.2U
* device instance $71 r0 *1 286.1,44.8 PMOS
M$71 Y \$4 VDD VDD PMOS L=1U W=10.2U AS=15.3P AD=15.3P PS=13.2U PD=13.2U
* device instance $72 r0 *1 290.1,44.8 PMOS
M$72 VDD \$4 Y VDD PMOS L=1U W=10.2U AS=15.3P AD=15.3P PS=13.2U PD=13.2U
* device instance $73 r0 *1 294.1,44.8 PMOS
M$73 Y \$4 VDD VDD PMOS L=1U W=10.2U AS=15.3P AD=15.3P PS=13.2U PD=13.2U
* device instance $74 r0 *1 298.1,44.8 PMOS
M$74 VDD \$4 Y VDD PMOS L=1U W=10.2U AS=15.3P AD=15.3P PS=13.2U PD=13.2U
* device instance $75 r0 *1 302.1,44.8 PMOS
M$75 Y \$4 VDD VDD PMOS L=1U W=10.2U AS=15.3P AD=15.3P PS=13.2U PD=13.2U
* device instance $76 r0 *1 306.1,44.8 PMOS
M$76 VDD \$4 Y VDD PMOS L=1U W=10.2U AS=15.3P AD=15.3P PS=13.2U PD=13.2U
* device instance $77 r0 *1 310.1,44.8 PMOS
M$77 Y \$4 VDD VDD PMOS L=1U W=10.2U AS=15.3P AD=15.3P PS=13.2U PD=13.2U
* device instance $78 r0 *1 314.1,44.8 PMOS
M$78 VDD \$4 Y VDD PMOS L=1U W=10.2U AS=15.3P AD=15.3P PS=13.2U PD=13.2U
* device instance $79 r0 *1 318.1,44.8 PMOS
M$79 Y \$4 VDD VDD PMOS L=1U W=10.2U AS=15.3P AD=15.3P PS=13.2U PD=13.2U
* device instance $80 r0 *1 322.1,44.8 PMOS
M$80 VDD \$4 Y VDD PMOS L=1U W=10.2U AS=15.3P AD=15.3P PS=13.2U PD=13.2U
* device instance $81 r0 *1 326.1,44.8 PMOS
M$81 Y \$4 VDD VDD PMOS L=1U W=10.2U AS=15.3P AD=15.3P PS=13.2U PD=13.2U
* device instance $82 r0 *1 330.1,44.8 PMOS
M$82 VDD \$4 Y VDD PMOS L=1U W=10.2U AS=15.3P AD=15.3P PS=13.2U PD=13.2U
* device instance $83 r0 *1 334.1,44.8 PMOS
M$83 Y \$4 VDD VDD PMOS L=1U W=10.2U AS=15.3P AD=15.3P PS=13.2U PD=13.2U
* device instance $84 r0 *1 338.1,44.8 PMOS
M$84 VDD \$4 Y VDD PMOS L=1U W=10.2U AS=15.3P AD=15.3P PS=13.2U PD=13.2U
* device instance $85 r0 *1 342.1,44.8 PMOS
M$85 Y \$4 VDD VDD PMOS L=1U W=10.2U AS=15.3P AD=15.3P PS=13.2U PD=13.2U
* device instance $86 r0 *1 346.1,44.8 PMOS
M$86 VDD \$4 Y VDD PMOS L=1U W=10.2U AS=15.3P AD=15.3P PS=13.2U PD=13.2U
* device instance $87 r0 *1 350.1,44.8 PMOS
M$87 Y \$4 VDD VDD PMOS L=1U W=10.2U AS=15.3P AD=15.3P PS=13.2U PD=13.2U
* device instance $88 r0 *1 354.1,44.8 PMOS
M$88 VDD \$4 Y VDD PMOS L=1U W=10.2U AS=15.3P AD=15.3P PS=13.2U PD=13.2U
* device instance $89 r0 *1 358.1,44.8 PMOS
M$89 Y \$4 VDD VDD PMOS L=1U W=10.2U AS=15.3P AD=15.3P PS=13.2U PD=13.2U
* device instance $90 r0 *1 362.1,44.8 PMOS
M$90 VDD \$4 Y VDD PMOS L=1U W=10.2U AS=15.3P AD=15.3P PS=13.2U PD=13.2U
* device instance $91 r0 *1 366.1,44.8 PMOS
M$91 Y \$4 VDD VDD PMOS L=1U W=10.2U AS=15.3P AD=15.3P PS=13.2U PD=13.2U
* device instance $92 r0 *1 370.1,44.8 PMOS
M$92 VDD \$4 Y VDD PMOS L=1U W=10.2U AS=15.3P AD=28.56P PS=13.2U PD=26U
* device instance $93 r0 *1 6.1,6.8 NMOS
M$93 \$4 A GND GND NMOS L=1U W=3.4U AS=9.52P AD=5.1P PS=12.4U PD=6.4U
* device instance $94 r0 *1 10.1,6.8 NMOS
M$94 GND A \$4 GND NMOS L=1U W=3.4U AS=5.1P AD=5.1P PS=6.4U PD=6.4U
* device instance $95 r0 *1 14.1,6.8 NMOS
M$95 \$4 A GND GND NMOS L=1U W=3.4U AS=5.1P AD=5.1P PS=6.4U PD=6.4U
* device instance $96 r0 *1 18.1,6.8 NMOS
M$96 GND A \$4 GND NMOS L=1U W=3.4U AS=5.1P AD=5.1P PS=6.4U PD=6.4U
* device instance $97 r0 *1 22.1,6.8 NMOS
M$97 \$4 A GND GND NMOS L=1U W=3.4U AS=5.1P AD=5.1P PS=6.4U PD=6.4U
* device instance $98 r0 *1 26.1,6.8 NMOS
M$98 GND A \$4 GND NMOS L=1U W=3.4U AS=5.1P AD=5.1P PS=6.4U PD=6.4U
* device instance $99 r0 *1 30.1,6.8 NMOS
M$99 \$4 A GND GND NMOS L=1U W=3.4U AS=5.1P AD=5.1P PS=6.4U PD=6.4U
* device instance $100 r0 *1 34.1,6.8 NMOS
M$100 GND A \$4 GND NMOS L=1U W=3.4U AS=5.1P AD=5.1P PS=6.4U PD=6.4U
* device instance $101 r0 *1 38.1,6.8 NMOS
M$101 \$4 A GND GND NMOS L=1U W=3.4U AS=5.1P AD=5.1P PS=6.4U PD=6.4U
* device instance $102 r0 *1 42.1,6.8 NMOS
M$102 GND A \$4 GND NMOS L=1U W=3.4U AS=5.1P AD=5.1P PS=6.4U PD=6.4U
* device instance $103 r0 *1 46.1,6.8 NMOS
M$103 \$4 A GND GND NMOS L=1U W=3.4U AS=5.1P AD=5.1P PS=6.4U PD=6.4U
* device instance $104 r0 *1 50.1,6.8 NMOS
M$104 GND A \$4 GND NMOS L=1U W=3.4U AS=5.1P AD=5.1P PS=6.4U PD=6.4U
* device instance $105 r0 *1 54.1,6.8 NMOS
M$105 Y \$4 GND GND NMOS L=1U W=3.4U AS=5.1P AD=5.1P PS=6.4U PD=6.4U
* device instance $106 r0 *1 58.1,6.8 NMOS
M$106 GND \$4 Y GND NMOS L=1U W=3.4U AS=5.1P AD=5.1P PS=6.4U PD=6.4U
* device instance $107 r0 *1 62.1,6.8 NMOS
M$107 Y \$4 GND GND NMOS L=1U W=3.4U AS=5.1P AD=5.1P PS=6.4U PD=6.4U
* device instance $108 r0 *1 66.1,6.8 NMOS
M$108 GND \$4 Y GND NMOS L=1U W=3.4U AS=5.1P AD=5.1P PS=6.4U PD=6.4U
* device instance $109 r0 *1 70.1,6.8 NMOS
M$109 Y \$4 GND GND NMOS L=1U W=3.4U AS=5.1P AD=5.1P PS=6.4U PD=6.4U
* device instance $110 r0 *1 74.1,6.8 NMOS
M$110 GND \$4 Y GND NMOS L=1U W=3.4U AS=5.1P AD=5.1P PS=6.4U PD=6.4U
* device instance $111 r0 *1 78.1,6.8 NMOS
M$111 Y \$4 GND GND NMOS L=1U W=3.4U AS=5.1P AD=5.1P PS=6.4U PD=6.4U
* device instance $112 r0 *1 82.1,6.8 NMOS
M$112 GND \$4 Y GND NMOS L=1U W=3.4U AS=5.1P AD=5.1P PS=6.4U PD=6.4U
* device instance $113 r0 *1 86.1,6.8 NMOS
M$113 Y \$4 GND GND NMOS L=1U W=3.4U AS=5.1P AD=5.1P PS=6.4U PD=6.4U
* device instance $114 r0 *1 90.1,6.8 NMOS
M$114 GND \$4 Y GND NMOS L=1U W=3.4U AS=5.1P AD=5.1P PS=6.4U PD=6.4U
* device instance $115 r0 *1 94.1,6.8 NMOS
M$115 Y \$4 GND GND NMOS L=1U W=3.4U AS=5.1P AD=5.1P PS=6.4U PD=6.4U
* device instance $116 r0 *1 98.1,6.8 NMOS
M$116 GND \$4 Y GND NMOS L=1U W=3.4U AS=5.1P AD=5.1P PS=6.4U PD=6.4U
* device instance $117 r0 *1 102.1,6.8 NMOS
M$117 Y \$4 GND GND NMOS L=1U W=3.4U AS=5.1P AD=5.1P PS=6.4U PD=6.4U
* device instance $118 r0 *1 106.1,6.8 NMOS
M$118 GND \$4 Y GND NMOS L=1U W=3.4U AS=5.1P AD=5.1P PS=6.4U PD=6.4U
* device instance $119 r0 *1 110.1,6.8 NMOS
M$119 Y \$4 GND GND NMOS L=1U W=3.4U AS=5.1P AD=5.1P PS=6.4U PD=6.4U
* device instance $120 r0 *1 114.1,6.8 NMOS
M$120 GND \$4 Y GND NMOS L=1U W=3.4U AS=5.1P AD=5.1P PS=6.4U PD=6.4U
* device instance $121 r0 *1 118.1,6.8 NMOS
M$121 Y \$4 GND GND NMOS L=1U W=3.4U AS=5.1P AD=5.1P PS=6.4U PD=6.4U
* device instance $122 r0 *1 122.1,6.8 NMOS
M$122 GND \$4 Y GND NMOS L=1U W=3.4U AS=5.1P AD=5.1P PS=6.4U PD=6.4U
* device instance $123 r0 *1 126.1,6.8 NMOS
M$123 Y \$4 GND GND NMOS L=1U W=3.4U AS=5.1P AD=5.1P PS=6.4U PD=6.4U
* device instance $124 r0 *1 130.1,6.8 NMOS
M$124 GND \$4 Y GND NMOS L=1U W=3.4U AS=5.1P AD=5.1P PS=6.4U PD=6.4U
* device instance $125 r0 *1 134.1,6.8 NMOS
M$125 Y \$4 GND GND NMOS L=1U W=3.4U AS=5.1P AD=5.1P PS=6.4U PD=6.4U
* device instance $126 r0 *1 138.1,6.8 NMOS
M$126 GND \$4 Y GND NMOS L=1U W=3.4U AS=5.1P AD=5.1P PS=6.4U PD=6.4U
* device instance $127 r0 *1 142.1,6.8 NMOS
M$127 Y \$4 GND GND NMOS L=1U W=3.4U AS=5.1P AD=5.1P PS=6.4U PD=6.4U
* device instance $128 r0 *1 146.1,6.8 NMOS
M$128 GND \$4 Y GND NMOS L=1U W=3.4U AS=5.1P AD=5.1P PS=6.4U PD=6.4U
* device instance $129 r0 *1 150.1,6.8 NMOS
M$129 Y \$4 GND GND NMOS L=1U W=3.4U AS=5.1P AD=5.1P PS=6.4U PD=6.4U
* device instance $130 r0 *1 154.1,6.8 NMOS
M$130 GND \$4 Y GND NMOS L=1U W=3.4U AS=5.1P AD=5.1P PS=6.4U PD=6.4U
* device instance $131 r0 *1 158.1,6.8 NMOS
M$131 Y \$4 GND GND NMOS L=1U W=3.4U AS=5.1P AD=5.1P PS=6.4U PD=6.4U
* device instance $132 r0 *1 162.1,6.8 NMOS
M$132 GND \$4 Y GND NMOS L=1U W=3.4U AS=5.1P AD=5.1P PS=6.4U PD=6.4U
* device instance $133 r0 *1 166.1,6.8 NMOS
M$133 Y \$4 GND GND NMOS L=1U W=3.4U AS=5.1P AD=5.1P PS=6.4U PD=6.4U
* device instance $134 r0 *1 170.1,6.8 NMOS
M$134 GND \$4 Y GND NMOS L=1U W=3.4U AS=5.1P AD=5.1P PS=6.4U PD=6.4U
* device instance $135 r0 *1 174.1,6.8 NMOS
M$135 Y \$4 GND GND NMOS L=1U W=3.4U AS=5.1P AD=5.1P PS=6.4U PD=6.4U
* device instance $136 r0 *1 178.1,6.8 NMOS
M$136 GND \$4 Y GND NMOS L=1U W=3.4U AS=5.1P AD=5.1P PS=6.4U PD=6.4U
* device instance $137 r0 *1 182.1,6.8 NMOS
M$137 Y \$4 GND GND NMOS L=1U W=3.4U AS=5.1P AD=5.1P PS=6.4U PD=6.4U
* device instance $138 r0 *1 186.1,6.8 NMOS
M$138 GND \$4 Y GND NMOS L=1U W=3.4U AS=5.1P AD=5.1P PS=6.4U PD=6.4U
* device instance $139 r0 *1 190.1,6.8 NMOS
M$139 Y \$4 GND GND NMOS L=1U W=3.4U AS=5.1P AD=5.1P PS=6.4U PD=6.4U
* device instance $140 r0 *1 194.1,6.8 NMOS
M$140 GND \$4 Y GND NMOS L=1U W=3.4U AS=5.1P AD=5.1P PS=6.4U PD=6.4U
* device instance $141 r0 *1 198.1,6.8 NMOS
M$141 Y \$4 GND GND NMOS L=1U W=3.4U AS=5.1P AD=5.1P PS=6.4U PD=6.4U
* device instance $142 r0 *1 202.1,6.8 NMOS
M$142 GND \$4 Y GND NMOS L=1U W=3.4U AS=5.1P AD=5.1P PS=6.4U PD=6.4U
* device instance $143 r0 *1 206.1,6.8 NMOS
M$143 Y \$4 GND GND NMOS L=1U W=3.4U AS=5.1P AD=5.1P PS=6.4U PD=6.4U
* device instance $144 r0 *1 210.1,6.8 NMOS
M$144 GND \$4 Y GND NMOS L=1U W=3.4U AS=5.1P AD=5.1P PS=6.4U PD=6.4U
* device instance $145 r0 *1 214.1,6.8 NMOS
M$145 Y \$4 GND GND NMOS L=1U W=3.4U AS=5.1P AD=5.1P PS=6.4U PD=6.4U
* device instance $146 r0 *1 218.1,6.8 NMOS
M$146 GND \$4 Y GND NMOS L=1U W=3.4U AS=5.1P AD=5.1P PS=6.4U PD=6.4U
* device instance $147 r0 *1 222.1,6.8 NMOS
M$147 Y \$4 GND GND NMOS L=1U W=3.4U AS=5.1P AD=5.1P PS=6.4U PD=6.4U
* device instance $148 r0 *1 226.1,6.8 NMOS
M$148 GND \$4 Y GND NMOS L=1U W=3.4U AS=5.1P AD=5.1P PS=6.4U PD=6.4U
* device instance $149 r0 *1 230.1,6.8 NMOS
M$149 Y \$4 GND GND NMOS L=1U W=3.4U AS=5.1P AD=5.1P PS=6.4U PD=6.4U
* device instance $150 r0 *1 234.1,6.8 NMOS
M$150 GND \$4 Y GND NMOS L=1U W=3.4U AS=5.1P AD=5.1P PS=6.4U PD=6.4U
* device instance $151 r0 *1 238.1,6.8 NMOS
M$151 Y \$4 GND GND NMOS L=1U W=3.4U AS=5.1P AD=5.1P PS=6.4U PD=6.4U
* device instance $152 r0 *1 242.1,6.8 NMOS
M$152 GND \$4 Y GND NMOS L=1U W=3.4U AS=5.1P AD=5.1P PS=6.4U PD=6.4U
* device instance $153 r0 *1 246.1,6.8 NMOS
M$153 Y \$4 GND GND NMOS L=1U W=3.4U AS=5.1P AD=5.1P PS=6.4U PD=6.4U
* device instance $154 r0 *1 250.1,6.8 NMOS
M$154 GND \$4 Y GND NMOS L=1U W=3.4U AS=5.1P AD=5.1P PS=6.4U PD=6.4U
* device instance $155 r0 *1 254.1,6.8 NMOS
M$155 Y \$4 GND GND NMOS L=1U W=3.4U AS=5.1P AD=5.1P PS=6.4U PD=6.4U
* device instance $156 r0 *1 258.1,6.8 NMOS
M$156 GND \$4 Y GND NMOS L=1U W=3.4U AS=5.1P AD=5.1P PS=6.4U PD=6.4U
* device instance $157 r0 *1 262.1,6.8 NMOS
M$157 Y \$4 GND GND NMOS L=1U W=3.4U AS=5.1P AD=5.1P PS=6.4U PD=6.4U
* device instance $158 r0 *1 266.1,6.8 NMOS
M$158 GND \$4 Y GND NMOS L=1U W=3.4U AS=5.1P AD=5.1P PS=6.4U PD=6.4U
* device instance $159 r0 *1 270.1,6.8 NMOS
M$159 Y \$4 GND GND NMOS L=1U W=3.4U AS=5.1P AD=5.1P PS=6.4U PD=6.4U
* device instance $160 r0 *1 274.1,6.8 NMOS
M$160 GND \$4 Y GND NMOS L=1U W=3.4U AS=5.1P AD=5.1P PS=6.4U PD=6.4U
* device instance $161 r0 *1 278.1,6.8 NMOS
M$161 Y \$4 GND GND NMOS L=1U W=3.4U AS=5.1P AD=5.1P PS=6.4U PD=6.4U
* device instance $162 r0 *1 282.1,6.8 NMOS
M$162 GND \$4 Y GND NMOS L=1U W=3.4U AS=5.1P AD=5.1P PS=6.4U PD=6.4U
* device instance $163 r0 *1 286.1,6.8 NMOS
M$163 Y \$4 GND GND NMOS L=1U W=3.4U AS=5.1P AD=5.1P PS=6.4U PD=6.4U
* device instance $164 r0 *1 290.1,6.8 NMOS
M$164 GND \$4 Y GND NMOS L=1U W=3.4U AS=5.1P AD=5.1P PS=6.4U PD=6.4U
* device instance $165 r0 *1 294.1,6.8 NMOS
M$165 Y \$4 GND GND NMOS L=1U W=3.4U AS=5.1P AD=5.1P PS=6.4U PD=6.4U
* device instance $166 r0 *1 298.1,6.8 NMOS
M$166 GND \$4 Y GND NMOS L=1U W=3.4U AS=5.1P AD=5.1P PS=6.4U PD=6.4U
* device instance $167 r0 *1 302.1,6.8 NMOS
M$167 Y \$4 GND GND NMOS L=1U W=3.4U AS=5.1P AD=5.1P PS=6.4U PD=6.4U
* device instance $168 r0 *1 306.1,6.8 NMOS
M$168 GND \$4 Y GND NMOS L=1U W=3.4U AS=5.1P AD=5.1P PS=6.4U PD=6.4U
* device instance $169 r0 *1 310.1,6.8 NMOS
M$169 Y \$4 GND GND NMOS L=1U W=3.4U AS=5.1P AD=5.1P PS=6.4U PD=6.4U
* device instance $170 r0 *1 314.1,6.8 NMOS
M$170 GND \$4 Y GND NMOS L=1U W=3.4U AS=5.1P AD=5.1P PS=6.4U PD=6.4U
* device instance $171 r0 *1 318.1,6.8 NMOS
M$171 Y \$4 GND GND NMOS L=1U W=3.4U AS=5.1P AD=5.1P PS=6.4U PD=6.4U
* device instance $172 r0 *1 322.1,6.8 NMOS
M$172 GND \$4 Y GND NMOS L=1U W=3.4U AS=5.1P AD=5.1P PS=6.4U PD=6.4U
* device instance $173 r0 *1 326.1,6.8 NMOS
M$173 Y \$4 GND GND NMOS L=1U W=3.4U AS=5.1P AD=5.1P PS=6.4U PD=6.4U
* device instance $174 r0 *1 330.1,6.8 NMOS
M$174 GND \$4 Y GND NMOS L=1U W=3.4U AS=5.1P AD=5.1P PS=6.4U PD=6.4U
* device instance $175 r0 *1 334.1,6.8 NMOS
M$175 Y \$4 GND GND NMOS L=1U W=3.4U AS=5.1P AD=5.1P PS=6.4U PD=6.4U
* device instance $176 r0 *1 338.1,6.8 NMOS
M$176 GND \$4 Y GND NMOS L=1U W=3.4U AS=5.1P AD=5.1P PS=6.4U PD=6.4U
* device instance $177 r0 *1 342.1,6.8 NMOS
M$177 Y \$4 GND GND NMOS L=1U W=3.4U AS=5.1P AD=5.1P PS=6.4U PD=6.4U
* device instance $178 r0 *1 346.1,6.8 NMOS
M$178 GND \$4 Y GND NMOS L=1U W=3.4U AS=5.1P AD=5.1P PS=6.4U PD=6.4U
* device instance $179 r0 *1 350.1,6.8 NMOS
M$179 Y \$4 GND GND NMOS L=1U W=3.4U AS=5.1P AD=5.1P PS=6.4U PD=6.4U
* device instance $180 r0 *1 354.1,6.8 NMOS
M$180 GND \$4 Y GND NMOS L=1U W=3.4U AS=5.1P AD=5.1P PS=6.4U PD=6.4U
* device instance $181 r0 *1 358.1,6.8 NMOS
M$181 Y \$4 GND GND NMOS L=1U W=3.4U AS=5.1P AD=5.1P PS=6.4U PD=6.4U
* device instance $182 r0 *1 362.1,6.8 NMOS
M$182 GND \$4 Y GND NMOS L=1U W=3.4U AS=5.1P AD=5.1P PS=6.4U PD=6.4U
* device instance $183 r0 *1 366.1,6.8 NMOS
M$183 Y \$4 GND GND NMOS L=1U W=3.4U AS=5.1P AD=5.1P PS=6.4U PD=6.4U
* device instance $184 r0 *1 370.1,6.8 NMOS
M$184 GND \$4 Y GND NMOS L=1U W=3.4U AS=5.1P AD=9.52P PS=6.4U PD=12.4U
.ENDS CLKBUF_X16

* ==== CLKBUF_X2 ====
* Created by KLayout

* cell CLKBUF_X2
* pin A
* pin Y
* pin VDD
* pin VSS
.SUBCKT CLKBUF_X2 A Y VDD GND
* device instance $1 r0 *1 6.1,44.8 PMOS
M$1 \$2 A VDD VDD PMOS L=1U W=10.2U AS=28.56P AD=15.3P PS=26U PD=13.2U
* device instance $2 r0 *1 10.1,44.8 PMOS
M$2 VDD A \$2 VDD PMOS L=1U W=10.2U AS=15.3P AD=15.3P PS=13.2U PD=13.2U
* device instance $3 r0 *1 14.1,44.8 PMOS
M$3 \$2 A VDD VDD PMOS L=1U W=10.2U AS=15.3P AD=15.3P PS=13.2U PD=13.2U
* device instance $4 r0 *1 18.1,44.8 PMOS
M$4 VDD A \$2 VDD PMOS L=1U W=10.2U AS=15.3P AD=15.3P PS=13.2U PD=13.2U
* device instance $5 r0 *1 22.1,44.8 PMOS
M$5 Y \$2 VDD VDD PMOS L=1U W=10.2U AS=15.3P AD=15.3P PS=13.2U PD=13.2U
* device instance $6 r0 *1 26.1,44.8 PMOS
M$6 VDD \$2 Y VDD PMOS L=1U W=10.2U AS=15.3P AD=15.3P PS=13.2U PD=13.2U
* device instance $7 r0 *1 30.1,44.8 PMOS
M$7 Y \$2 VDD VDD PMOS L=1U W=10.2U AS=15.3P AD=15.3P PS=13.2U PD=13.2U
* device instance $8 r0 *1 34.1,44.8 PMOS
M$8 VDD \$2 Y VDD PMOS L=1U W=10.2U AS=15.3P AD=15.3P PS=13.2U PD=13.2U
* device instance $9 r0 *1 38.1,44.8 PMOS
M$9 Y \$2 VDD VDD PMOS L=1U W=10.2U AS=15.3P AD=15.3P PS=13.2U PD=13.2U
* device instance $10 r0 *1 42.1,44.8 PMOS
M$10 VDD \$2 Y VDD PMOS L=1U W=10.2U AS=15.3P AD=15.3P PS=13.2U PD=13.2U
* device instance $11 r0 *1 46.1,44.8 PMOS
M$11 Y \$2 VDD VDD PMOS L=1U W=10.2U AS=15.3P AD=15.3P PS=13.2U PD=13.2U
* device instance $12 r0 *1 50.1,44.8 PMOS
M$12 VDD \$2 Y VDD PMOS L=1U W=10.2U AS=15.3P AD=15.3P PS=13.2U PD=13.2U
* device instance $13 r0 *1 54.1,44.8 PMOS
M$13 Y \$2 VDD VDD PMOS L=1U W=10.2U AS=15.3P AD=15.3P PS=13.2U PD=13.2U
* device instance $14 r0 *1 58.1,44.8 PMOS
M$14 VDD \$2 Y VDD PMOS L=1U W=10.2U AS=15.3P AD=28.56P PS=13.2U PD=26U
* device instance $15 r0 *1 6.1,6.8 NMOS
M$15 \$2 A GND GND NMOS L=1U W=3.4U AS=9.52P AD=5.1P PS=12.4U PD=6.4U
* device instance $16 r0 *1 10.1,6.8 NMOS
M$16 GND A \$2 GND NMOS L=1U W=3.4U AS=5.1P AD=5.1P PS=6.4U PD=6.4U
* device instance $17 r0 *1 14.1,6.8 NMOS
M$17 \$2 A GND GND NMOS L=1U W=3.4U AS=5.1P AD=5.1P PS=6.4U PD=6.4U
* device instance $18 r0 *1 18.1,6.8 NMOS
M$18 GND A \$2 GND NMOS L=1U W=3.4U AS=5.1P AD=5.1P PS=6.4U PD=6.4U
* device instance $19 r0 *1 22.1,6.8 NMOS
M$19 Y \$2 GND GND NMOS L=1U W=3.4U AS=5.1P AD=5.1P PS=6.4U PD=6.4U
* device instance $20 r0 *1 26.1,6.8 NMOS
M$20 GND \$2 Y GND NMOS L=1U W=3.4U AS=5.1P AD=5.1P PS=6.4U PD=6.4U
* device instance $21 r0 *1 30.1,6.8 NMOS
M$21 Y \$2 GND GND NMOS L=1U W=3.4U AS=5.1P AD=5.1P PS=6.4U PD=6.4U
* device instance $22 r0 *1 34.1,6.8 NMOS
M$22 GND \$2 Y GND NMOS L=1U W=3.4U AS=5.1P AD=5.1P PS=6.4U PD=6.4U
* device instance $23 r0 *1 38.1,6.8 NMOS
M$23 Y \$2 GND GND NMOS L=1U W=3.4U AS=5.1P AD=5.1P PS=6.4U PD=6.4U
* device instance $24 r0 *1 42.1,6.8 NMOS
M$24 GND \$2 Y GND NMOS L=1U W=3.4U AS=5.1P AD=5.1P PS=6.4U PD=6.4U
* device instance $25 r0 *1 46.1,6.8 NMOS
M$25 Y \$2 GND GND NMOS L=1U W=3.4U AS=5.1P AD=5.1P PS=6.4U PD=6.4U
* device instance $26 r0 *1 50.1,6.8 NMOS
M$26 GND \$2 Y GND NMOS L=1U W=3.4U AS=5.1P AD=5.1P PS=6.4U PD=6.4U
* device instance $27 r0 *1 54.1,6.8 NMOS
M$27 Y \$2 GND GND NMOS L=1U W=3.4U AS=5.1P AD=5.1P PS=6.4U PD=6.4U
* device instance $28 r0 *1 58.1,6.8 NMOS
M$28 GND \$2 Y GND NMOS L=1U W=3.4U AS=5.1P AD=9.52P PS=6.4U PD=12.4U
.ENDS CLKBUF_X2

* ==== CLKBUF_X4 ====
* Created by KLayout
* pin A
* pin Y
* pin VDD
* pin GND
* pin A
* pin Y
* pin VDD
* pin GND
.SUBCKT CLKBUF_X4 A Y VDD GND
* device instance $1 r0 *1 12.4,46.1 PMOS
M$1 VDD A \$4 VDD PMOS L=1u W=61.2u AS=105.06p AD=91.8p PS=92u PD=79.2u
* device instance $7 r0 *1 36.4,46.1 PMOS
M$7 VDD \$4 Y VDD PMOS L=1u W=204u AS=306p AD=319.26p PS=264u PD=276.8u
* device instance $27 r0 *1 12.4,8.1 NMOS
M$27 GND A \$4 GND NMOS L=1u W=20.4u AS=35.02p AD=30.6p PS=44.4u PD=38.4u
* device instance $33 r0 *1 36.4,8.1 NMOS
M$33 GND \$4 Y GND NMOS L=1u W=68u AS=102p AD=106.42p PS=128u PD=134u
.ENDS CLKBUF_X4
* ==== CLKBUF_X8 ====
* Created by KLayout

* cell CLKBUF_X8
* pin Y
* pin A
* pin VDD
* pin GND
.SUBCKT CLKBUF_X8 Y A VDD GND
* device instance $1 r0 *1 6.1,44.8 PMOS
M$1 \$4 A VDD VDD PMOS L=1U W=10.2U AS=28.56P AD=15.3P PS=26U PD=13.2U
* device instance $2 r0 *1 10.1,44.8 PMOS
M$2 VDD A \$4 VDD PMOS L=1U W=10.2U AS=15.3P AD=15.3P PS=13.2U PD=13.2U
* device instance $3 r0 *1 14.1,44.8 PMOS
M$3 \$4 A VDD VDD PMOS L=1U W=10.2U AS=15.3P AD=15.3P PS=13.2U PD=13.2U
* device instance $4 r0 *1 18.1,44.8 PMOS
M$4 VDD A \$4 VDD PMOS L=1U W=10.2U AS=15.3P AD=15.3P PS=13.2U PD=13.2U
* device instance $5 r0 *1 22.1,44.8 PMOS
M$5 \$4 A VDD VDD PMOS L=1U W=10.2U AS=15.3P AD=15.3P PS=13.2U PD=13.2U
* device instance $6 r0 *1 26.1,44.8 PMOS
M$6 VDD A \$4 VDD PMOS L=1U W=10.2U AS=15.3P AD=15.3P PS=13.2U PD=13.2U
* device instance $7 r0 *1 30.1,44.8 PMOS
M$7 \$4 A VDD VDD PMOS L=1U W=10.2U AS=15.3P AD=15.3P PS=13.2U PD=13.2U
* device instance $8 r0 *1 34.1,44.8 PMOS
M$8 VDD A \$4 VDD PMOS L=1U W=10.2U AS=15.3P AD=15.3P PS=13.2U PD=13.2U
* device instance $9 r0 *1 38.1,44.8 PMOS
M$9 Y \$4 VDD VDD PMOS L=1U W=10.2U AS=15.3P AD=15.3P PS=13.2U PD=13.2U
* device instance $10 r0 *1 42.1,44.8 PMOS
M$10 VDD \$4 Y VDD PMOS L=1U W=10.2U AS=15.3P AD=15.3P PS=13.2U PD=13.2U
* device instance $11 r0 *1 46.1,44.8 PMOS
M$11 Y \$4 VDD VDD PMOS L=1U W=10.2U AS=15.3P AD=15.3P PS=13.2U PD=13.2U
* device instance $12 r0 *1 50.1,44.8 PMOS
M$12 VDD \$4 Y VDD PMOS L=1U W=10.2U AS=15.3P AD=15.3P PS=13.2U PD=13.2U
* device instance $13 r0 *1 54.1,44.8 PMOS
M$13 Y \$4 VDD VDD PMOS L=1U W=10.2U AS=15.3P AD=15.3P PS=13.2U PD=13.2U
* device instance $14 r0 *1 58.1,44.8 PMOS
M$14 VDD \$4 Y VDD PMOS L=1U W=10.2U AS=15.3P AD=15.3P PS=13.2U PD=13.2U
* device instance $15 r0 *1 62.1,44.8 PMOS
M$15 Y \$4 VDD VDD PMOS L=1U W=10.2U AS=15.3P AD=15.3P PS=13.2U PD=13.2U
* device instance $16 r0 *1 66.1,44.8 PMOS
M$16 VDD \$4 Y VDD PMOS L=1U W=10.2U AS=15.3P AD=15.3P PS=13.2U PD=13.2U
* device instance $17 r0 *1 70.1,44.8 PMOS
M$17 Y \$4 VDD VDD PMOS L=1U W=10.2U AS=15.3P AD=15.3P PS=13.2U PD=13.2U
* device instance $18 r0 *1 74.1,44.8 PMOS
M$18 VDD \$4 Y VDD PMOS L=1U W=10.2U AS=15.3P AD=15.3P PS=13.2U PD=13.2U
* device instance $19 r0 *1 78.1,44.8 PMOS
M$19 Y \$4 VDD VDD PMOS L=1U W=10.2U AS=15.3P AD=15.3P PS=13.2U PD=13.2U
* device instance $20 r0 *1 82.1,44.8 PMOS
M$20 VDD \$4 Y VDD PMOS L=1U W=10.2U AS=15.3P AD=15.3P PS=13.2U PD=13.2U
* device instance $21 r0 *1 86.1,44.8 PMOS
M$21 Y \$4 VDD VDD PMOS L=1U W=10.2U AS=15.3P AD=15.3P PS=13.2U PD=13.2U
* device instance $22 r0 *1 90.1,44.8 PMOS
M$22 VDD \$4 Y VDD PMOS L=1U W=10.2U AS=15.3P AD=15.3P PS=13.2U PD=13.2U
* device instance $23 r0 *1 94.1,44.8 PMOS
M$23 Y \$4 VDD VDD PMOS L=1U W=10.2U AS=15.3P AD=15.3P PS=13.2U PD=13.2U
* device instance $24 r0 *1 98.1,44.8 PMOS
M$24 VDD \$4 Y VDD PMOS L=1U W=10.2U AS=15.3P AD=15.3P PS=13.2U PD=13.2U
* device instance $25 r0 *1 102.1,44.8 PMOS
M$25 Y \$4 VDD VDD PMOS L=1U W=10.2U AS=15.3P AD=15.3P PS=13.2U PD=13.2U
* device instance $26 r0 *1 106.1,44.8 PMOS
M$26 VDD \$4 Y VDD PMOS L=1U W=10.2U AS=15.3P AD=15.3P PS=13.2U PD=13.2U
* device instance $27 r0 *1 110.1,44.8 PMOS
M$27 Y \$4 VDD VDD PMOS L=1U W=10.2U AS=15.3P AD=15.3P PS=13.2U PD=13.2U
* device instance $28 r0 *1 114.1,44.8 PMOS
M$28 VDD \$4 Y VDD PMOS L=1U W=10.2U AS=15.3P AD=15.3P PS=13.2U PD=13.2U
* device instance $29 r0 *1 118.1,44.8 PMOS
M$29 Y \$4 VDD VDD PMOS L=1U W=10.2U AS=15.3P AD=15.3P PS=13.2U PD=13.2U
* device instance $30 r0 *1 122.1,44.8 PMOS
M$30 VDD \$4 Y VDD PMOS L=1U W=10.2U AS=15.3P AD=15.3P PS=13.2U PD=13.2U
* device instance $31 r0 *1 126.1,44.8 PMOS
M$31 Y \$4 VDD VDD PMOS L=1U W=10.2U AS=15.3P AD=15.3P PS=13.2U PD=13.2U
* device instance $32 r0 *1 130.1,44.8 PMOS
M$32 VDD \$4 Y VDD PMOS L=1U W=10.2U AS=15.3P AD=15.3P PS=13.2U PD=13.2U
* device instance $33 r0 *1 134.1,44.8 PMOS
M$33 Y \$4 VDD VDD PMOS L=1U W=10.2U AS=15.3P AD=15.3P PS=13.2U PD=13.2U
* device instance $34 r0 *1 138.1,44.8 PMOS
M$34 VDD \$4 Y VDD PMOS L=1U W=10.2U AS=15.3P AD=15.3P PS=13.2U PD=13.2U
* device instance $35 r0 *1 142.1,44.8 PMOS
M$35 Y \$4 VDD VDD PMOS L=1U W=10.2U AS=15.3P AD=15.3P PS=13.2U PD=13.2U
* device instance $36 r0 *1 146.1,44.8 PMOS
M$36 VDD \$4 Y VDD PMOS L=1U W=10.2U AS=15.3P AD=15.3P PS=13.2U PD=13.2U
* device instance $37 r0 *1 150.1,44.8 PMOS
M$37 Y \$4 VDD VDD PMOS L=1U W=10.2U AS=15.3P AD=15.3P PS=13.2U PD=13.2U
* device instance $38 r0 *1 154.1,44.8 PMOS
M$38 VDD \$4 Y VDD PMOS L=1U W=10.2U AS=15.3P AD=15.3P PS=13.2U PD=13.2U
* device instance $39 r0 *1 158.1,44.8 PMOS
M$39 Y \$4 VDD VDD PMOS L=1U W=10.2U AS=15.3P AD=15.3P PS=13.2U PD=13.2U
* device instance $40 r0 *1 162.1,44.8 PMOS
M$40 VDD \$4 Y VDD PMOS L=1U W=10.2U AS=15.3P AD=15.3P PS=13.2U PD=13.2U
* device instance $41 r0 *1 166.1,44.8 PMOS
M$41 Y \$4 VDD VDD PMOS L=1U W=10.2U AS=15.3P AD=15.3P PS=13.2U PD=13.2U
* device instance $42 r0 *1 170.1,44.8 PMOS
M$42 VDD \$4 Y VDD PMOS L=1U W=10.2U AS=15.3P AD=15.3P PS=13.2U PD=13.2U
* device instance $43 r0 *1 174.1,44.8 PMOS
M$43 Y \$4 VDD VDD PMOS L=1U W=10.2U AS=15.3P AD=15.3P PS=13.2U PD=13.2U
* device instance $44 r0 *1 178.1,44.8 PMOS
M$44 VDD \$4 Y VDD PMOS L=1U W=10.2U AS=15.3P AD=15.3P PS=13.2U PD=13.2U
* device instance $45 r0 *1 182.1,44.8 PMOS
M$45 Y \$4 VDD VDD PMOS L=1U W=10.2U AS=15.3P AD=15.3P PS=13.2U PD=13.2U
* device instance $46 r0 *1 186.1,44.8 PMOS
M$46 VDD \$4 Y VDD PMOS L=1U W=10.2U AS=15.3P AD=15.3P PS=13.2U PD=13.2U
* device instance $47 r0 *1 190.1,44.8 PMOS
M$47 Y \$4 VDD VDD PMOS L=1U W=10.2U AS=15.3P AD=15.3P PS=13.2U PD=13.2U
* device instance $48 r0 *1 194.1,44.8 PMOS
M$48 VDD \$4 Y VDD PMOS L=1U W=10.2U AS=15.3P AD=28.56P PS=13.2U PD=26U
* device instance $49 r0 *1 6.1,6.8 NMOS
M$49 \$4 A GND GND NMOS L=1U W=3.4U AS=9.52P AD=5.1P PS=12.4U PD=6.4U
* device instance $50 r0 *1 10.1,6.8 NMOS
M$50 GND A \$4 GND NMOS L=1U W=3.4U AS=5.1P AD=5.1P PS=6.4U PD=6.4U
* device instance $51 r0 *1 14.1,6.8 NMOS
M$51 \$4 A GND GND NMOS L=1U W=3.4U AS=5.1P AD=5.1P PS=6.4U PD=6.4U
* device instance $52 r0 *1 18.1,6.8 NMOS
M$52 GND A \$4 GND NMOS L=1U W=3.4U AS=5.1P AD=5.1P PS=6.4U PD=6.4U
* device instance $53 r0 *1 22.1,6.8 NMOS
M$53 \$4 A GND GND NMOS L=1U W=3.4U AS=5.1P AD=5.1P PS=6.4U PD=6.4U
* device instance $54 r0 *1 26.1,6.8 NMOS
M$54 GND A \$4 GND NMOS L=1U W=3.4U AS=5.1P AD=5.1P PS=6.4U PD=6.4U
* device instance $55 r0 *1 30.1,6.8 NMOS
M$55 \$4 A GND GND NMOS L=1U W=3.4U AS=5.1P AD=5.1P PS=6.4U PD=6.4U
* device instance $56 r0 *1 34.1,6.8 NMOS
M$56 GND A \$4 GND NMOS L=1U W=3.4U AS=5.1P AD=5.1P PS=6.4U PD=6.4U
* device instance $57 r0 *1 38.1,6.8 NMOS
M$57 Y \$4 GND GND NMOS L=1U W=3.4U AS=5.1P AD=5.1P PS=6.4U PD=6.4U
* device instance $58 r0 *1 42.1,6.8 NMOS
M$58 GND \$4 Y GND NMOS L=1U W=3.4U AS=5.1P AD=5.1P PS=6.4U PD=6.4U
* device instance $59 r0 *1 46.1,6.8 NMOS
M$59 Y \$4 GND GND NMOS L=1U W=3.4U AS=5.1P AD=5.1P PS=6.4U PD=6.4U
* device instance $60 r0 *1 50.1,6.8 NMOS
M$60 GND \$4 Y GND NMOS L=1U W=3.4U AS=5.1P AD=5.1P PS=6.4U PD=6.4U
* device instance $61 r0 *1 54.1,6.8 NMOS
M$61 Y \$4 GND GND NMOS L=1U W=3.4U AS=5.1P AD=5.1P PS=6.4U PD=6.4U
* device instance $62 r0 *1 58.1,6.8 NMOS
M$62 GND \$4 Y GND NMOS L=1U W=3.4U AS=5.1P AD=5.1P PS=6.4U PD=6.4U
* device instance $63 r0 *1 62.1,6.8 NMOS
M$63 Y \$4 GND GND NMOS L=1U W=3.4U AS=5.1P AD=5.1P PS=6.4U PD=6.4U
* device instance $64 r0 *1 66.1,6.8 NMOS
M$64 GND \$4 Y GND NMOS L=1U W=3.4U AS=5.1P AD=5.1P PS=6.4U PD=6.4U
* device instance $65 r0 *1 70.1,6.8 NMOS
M$65 Y \$4 GND GND NMOS L=1U W=3.4U AS=5.1P AD=5.1P PS=6.4U PD=6.4U
* device instance $66 r0 *1 74.1,6.8 NMOS
M$66 GND \$4 Y GND NMOS L=1U W=3.4U AS=5.1P AD=5.1P PS=6.4U PD=6.4U
* device instance $67 r0 *1 78.1,6.8 NMOS
M$67 Y \$4 GND GND NMOS L=1U W=3.4U AS=5.1P AD=5.1P PS=6.4U PD=6.4U
* device instance $68 r0 *1 82.1,6.8 NMOS
M$68 GND \$4 Y GND NMOS L=1U W=3.4U AS=5.1P AD=5.1P PS=6.4U PD=6.4U
* device instance $69 r0 *1 86.1,6.8 NMOS
M$69 Y \$4 GND GND NMOS L=1U W=3.4U AS=5.1P AD=5.1P PS=6.4U PD=6.4U
* device instance $70 r0 *1 90.1,6.8 NMOS
M$70 GND \$4 Y GND NMOS L=1U W=3.4U AS=5.1P AD=5.1P PS=6.4U PD=6.4U
* device instance $71 r0 *1 94.1,6.8 NMOS
M$71 Y \$4 GND GND NMOS L=1U W=3.4U AS=5.1P AD=5.1P PS=6.4U PD=6.4U
* device instance $72 r0 *1 98.1,6.8 NMOS
M$72 GND \$4 Y GND NMOS L=1U W=3.4U AS=5.1P AD=5.1P PS=6.4U PD=6.4U
* device instance $73 r0 *1 102.1,6.8 NMOS
M$73 Y \$4 GND GND NMOS L=1U W=3.4U AS=5.1P AD=5.1P PS=6.4U PD=6.4U
* device instance $74 r0 *1 106.1,6.8 NMOS
M$74 GND \$4 Y GND NMOS L=1U W=3.4U AS=5.1P AD=5.1P PS=6.4U PD=6.4U
* device instance $75 r0 *1 110.1,6.8 NMOS
M$75 Y \$4 GND GND NMOS L=1U W=3.4U AS=5.1P AD=5.1P PS=6.4U PD=6.4U
* device instance $76 r0 *1 114.1,6.8 NMOS
M$76 GND \$4 Y GND NMOS L=1U W=3.4U AS=5.1P AD=5.1P PS=6.4U PD=6.4U
* device instance $77 r0 *1 118.1,6.8 NMOS
M$77 Y \$4 GND GND NMOS L=1U W=3.4U AS=5.1P AD=5.1P PS=6.4U PD=6.4U
* device instance $78 r0 *1 122.1,6.8 NMOS
M$78 GND \$4 Y GND NMOS L=1U W=3.4U AS=5.1P AD=5.1P PS=6.4U PD=6.4U
* device instance $79 r0 *1 126.1,6.8 NMOS
M$79 Y \$4 GND GND NMOS L=1U W=3.4U AS=5.1P AD=5.1P PS=6.4U PD=6.4U
* device instance $80 r0 *1 130.1,6.8 NMOS
M$80 GND \$4 Y GND NMOS L=1U W=3.4U AS=5.1P AD=5.1P PS=6.4U PD=6.4U
* device instance $81 r0 *1 134.1,6.8 NMOS
M$81 Y \$4 GND GND NMOS L=1U W=3.4U AS=5.1P AD=5.1P PS=6.4U PD=6.4U
* device instance $82 r0 *1 138.1,6.8 NMOS
M$82 GND \$4 Y GND NMOS L=1U W=3.4U AS=5.1P AD=5.1P PS=6.4U PD=6.4U
* device instance $83 r0 *1 142.1,6.8 NMOS
M$83 Y \$4 GND GND NMOS L=1U W=3.4U AS=5.1P AD=5.1P PS=6.4U PD=6.4U
* device instance $84 r0 *1 146.1,6.8 NMOS
M$84 GND \$4 Y GND NMOS L=1U W=3.4U AS=5.1P AD=5.1P PS=6.4U PD=6.4U
* device instance $85 r0 *1 150.1,6.8 NMOS
M$85 Y \$4 GND GND NMOS L=1U W=3.4U AS=5.1P AD=5.1P PS=6.4U PD=6.4U
* device instance $86 r0 *1 154.1,6.8 NMOS
M$86 GND \$4 Y GND NMOS L=1U W=3.4U AS=5.1P AD=5.1P PS=6.4U PD=6.4U
* device instance $87 r0 *1 158.1,6.8 NMOS
M$87 Y \$4 GND GND NMOS L=1U W=3.4U AS=5.1P AD=5.1P PS=6.4U PD=6.4U
* device instance $88 r0 *1 162.1,6.8 NMOS
M$88 GND \$4 Y GND NMOS L=1U W=3.4U AS=5.1P AD=5.1P PS=6.4U PD=6.4U
* device instance $89 r0 *1 166.1,6.8 NMOS
M$89 Y \$4 GND GND NMOS L=1U W=3.4U AS=5.1P AD=5.1P PS=6.4U PD=6.4U
* device instance $90 r0 *1 170.1,6.8 NMOS
M$90 GND \$4 Y GND NMOS L=1U W=3.4U AS=5.1P AD=5.1P PS=6.4U PD=6.4U
* device instance $91 r0 *1 174.1,6.8 NMOS
M$91 Y \$4 GND GND NMOS L=1U W=3.4U AS=5.1P AD=5.1P PS=6.4U PD=6.4U
* device instance $92 r0 *1 178.1,6.8 NMOS
M$92 GND \$4 Y GND NMOS L=1U W=3.4U AS=5.1P AD=5.1P PS=6.4U PD=6.4U
* device instance $93 r0 *1 182.1,6.8 NMOS
M$93 Y \$4 GND GND NMOS L=1U W=3.4U AS=5.1P AD=5.1P PS=6.4U PD=6.4U
* device instance $94 r0 *1 186.1,6.8 NMOS
M$94 GND \$4 Y GND NMOS L=1U W=3.4U AS=5.1P AD=5.1P PS=6.4U PD=6.4U
* device instance $95 r0 *1 190.1,6.8 NMOS
M$95 Y \$4 GND GND NMOS L=1U W=3.4U AS=5.1P AD=5.1P PS=6.4U PD=6.4U
* device instance $96 r0 *1 194.1,6.8 NMOS
M$96 GND \$4 Y GND NMOS L=1U W=3.4U AS=5.1P AD=9.52P PS=6.4U PD=12.4U
.ENDS CLKBUF_X8

* ==== DEL1 ====
* Created by KLayout

* cell DEL1
* pin Y
* pin A
* pin VDD
* pin GND
.SUBCKT DEL1 Y A VDD GND
* device instance $1 r0 *1 19.6,44.8 PMOS
M$1 VDD \$3 \$4 VDD PMOS L=2U W=10.2U AS=28.56P AD=15.3P PS=26U PD=13.2U
* device instance $2 r0 *1 24.1,44.8 PMOS
M$2 Y \$4 VDD VDD PMOS L=1U W=10.2U AS=15.3P AD=15.3P PS=13.2U PD=13.2U
* device instance $3 r0 *1 28.1,44.8 PMOS
M$3 VDD \$4 Y VDD PMOS L=1U W=10.2U AS=15.3P AD=28.56P PS=13.2U PD=26U
* device instance $4 r0 *1 6.1,44.8 PMOS
M$4 VDD A \$2 VDD PMOS L=1U W=10.2U AS=28.56P AD=15.3P PS=26U PD=13.2U
* device instance $5 r0 *1 10.6,44.8 PMOS
M$5 \$3 \$2 VDD VDD PMOS L=2U W=10.2U AS=15.3P AD=28.56P PS=13.2U PD=26U
* device instance $6 r0 *1 19.6,6.8 NMOS
M$6 GND \$3 \$4 GND NMOS L=2U W=3.4U AS=9.52P AD=5.1P PS=12.4U PD=6.4U
* device instance $7 r0 *1 24.1,6.8 NMOS
M$7 Y \$4 GND GND NMOS L=1U W=3.4U AS=5.1P AD=5.1P PS=6.4U PD=6.4U
* device instance $8 r0 *1 28.1,6.8 NMOS
M$8 GND \$4 Y GND NMOS L=1U W=3.4U AS=5.1P AD=9.52P PS=6.4U PD=12.4U
* device instance $9 r0 *1 6.1,6.8 NMOS
M$9 GND A \$2 GND NMOS L=1U W=3.4U AS=9.52P AD=5.1P PS=12.4U PD=6.4U
* device instance $10 r0 *1 10.6,6.8 NMOS
M$10 \$3 \$2 GND GND NMOS L=2U W=3.4U AS=5.1P AD=9.52P PS=6.4U PD=12.4U
.ENDS DEL1

* ==== DEL2 ====
* Created by KLayout

* cell DEL2
* pin Y
* pin A
* pin VDD
* pin GND
.SUBCKT DEL2 Y A VDD GND
* device instance $1 r0 *1 24.6,44.8 PMOS
M$1 VDD \$3 \$4 VDD PMOS L=8U W=10.2U AS=28.56P AD=15.3P PS=26U PD=13.2U
* device instance $2 r0 *1 34.6,44.8 PMOS
M$2 \$5 \$4 VDD VDD PMOS L=6U W=10.2U AS=15.3P AD=28.56P PS=13.2U PD=26U
* device instance $3 r0 *1 6.1,44.8 PMOS
M$3 VDD A \$2 VDD PMOS L=1U W=10.2U AS=28.56P AD=15.3P PS=26U PD=13.2U
* device instance $4 r0 *1 11.6,44.8 PMOS
M$4 \$3 \$2 VDD VDD PMOS L=4U W=10.2U AS=15.3P AD=28.56P PS=13.2U PD=26U
* device instance $5 r0 *1 46.6,44.8 PMOS
M$5 VDD \$5 \$6 VDD PMOS L=4U W=10.2U AS=28.56P AD=15.3P PS=26U PD=13.2U
* device instance $6 r0 *1 52.1,44.8 PMOS
M$6 Y \$6 VDD VDD PMOS L=1U W=10.2U AS=15.3P AD=28.56P PS=13.2U PD=26U
* device instance $7 r0 *1 46.6,6.8 NMOS
M$7 GND \$5 \$6 GND NMOS L=4U W=3.4U AS=9.52P AD=5.1P PS=12.4U PD=6.4U
* device instance $8 r0 *1 52.1,6.8 NMOS
M$8 Y \$6 GND GND NMOS L=1U W=3.4U AS=5.1P AD=9.52P PS=6.4U PD=12.4U
* device instance $9 r0 *1 6.1,6.8 NMOS
M$9 GND A \$2 GND NMOS L=1U W=3.4U AS=9.52P AD=5.1P PS=12.4U PD=6.4U
* device instance $10 r0 *1 11.6,6.8 NMOS
M$10 \$3 \$2 GND GND NMOS L=4U W=3.4U AS=5.1P AD=9.52P PS=6.4U PD=12.4U
* device instance $11 r0 *1 24.6,6.8 NMOS
M$11 GND \$3 \$4 GND NMOS L=8U W=3.4U AS=9.52P AD=5.1P PS=12.4U PD=6.4U
* device instance $12 r0 *1 34.6,6.8 NMOS
M$12 \$5 \$4 GND GND NMOS L=6U W=3.4U AS=5.1P AD=9.52P PS=6.4U PD=12.4U
.ENDS DEL2

* ==== DEL4 ====
* Created by KLayout

* cell DEL4
* pin Y
* pin A
* pin VDD
* pin GND
.SUBCKT DEL4 Y A VDD GND
* device instance $1 r0 *1 88.6,44.8 PMOS
M$1 VDD \$7 \$8 VDD PMOS L=6U W=10.2U AS=28.56P AD=15.3P PS=26U PD=13.2U
* device instance $2 r0 *1 95.1,44.8 PMOS
M$2 Y \$8 VDD VDD PMOS L=1U W=10.2U AS=15.3P AD=28.56P PS=13.2U PD=26U
* device instance $3 r0 *1 65.6,44.8 PMOS
M$3 VDD \$5 \$6 VDD PMOS L=8U W=10.2U AS=28.56P AD=15.3P PS=26U PD=13.2U
* device instance $4 r0 *1 75.6,44.8 PMOS
M$4 \$7 \$6 VDD VDD PMOS L=6U W=10.2U AS=15.3P AD=28.56P PS=13.2U PD=26U
* device instance $5 r0 *1 33.6,44.8 PMOS
M$5 VDD \$3 \$4 VDD PMOS L=12U W=10.2U AS=28.56P AD=15.3P PS=26U PD=13.2U
* device instance $6 r0 *1 48.6,44.8 PMOS
M$6 \$5 \$4 VDD VDD PMOS L=12U W=10.2U AS=15.3P AD=28.56P PS=13.2U PD=26U
* device instance $7 r0 *1 7.6,44.8 PMOS
M$7 VDD A \$2 VDD PMOS L=4U W=10.2U AS=28.56P AD=15.3P PS=26U PD=13.2U
* device instance $8 r0 *1 16.6,44.8 PMOS
M$8 \$3 \$2 VDD VDD PMOS L=8U W=10.2U AS=15.3P AD=28.56P PS=13.2U PD=26U
* device instance $9 r0 *1 88.6,6.8 NMOS
M$9 GND \$7 \$8 GND NMOS L=6U W=3.4U AS=9.52P AD=5.1P PS=12.4U PD=6.4U
* device instance $10 r0 *1 95.1,6.8 NMOS
M$10 Y \$8 GND GND NMOS L=1U W=3.4U AS=5.1P AD=9.52P PS=6.4U PD=12.4U
* device instance $11 r0 *1 7.6,6.8 NMOS
M$11 GND A \$2 GND NMOS L=4U W=3.4U AS=9.52P AD=5.1P PS=12.4U PD=6.4U
* device instance $12 r0 *1 16.6,6.8 NMOS
M$12 \$3 \$2 GND GND NMOS L=8U W=3.4U AS=5.1P AD=9.52P PS=6.4U PD=12.4U
* device instance $13 r0 *1 33.6,6.8 NMOS
M$13 GND \$3 \$4 GND NMOS L=12U W=3.4U AS=9.52P AD=5.1P PS=12.4U PD=6.4U
* device instance $14 r0 *1 48.6,6.8 NMOS
M$14 \$5 \$4 GND GND NMOS L=12U W=3.4U AS=5.1P AD=9.52P PS=6.4U PD=12.4U
* device instance $15 r0 *1 65.6,6.8 NMOS
M$15 GND \$5 \$6 GND NMOS L=8U W=3.4U AS=9.52P AD=5.1P PS=12.4U PD=6.4U
* device instance $16 r0 *1 75.6,6.8 NMOS
M$16 \$7 \$6 GND GND NMOS L=6U W=3.4U AS=5.1P AD=9.52P PS=6.4U PD=12.4U
.ENDS DEL4

* ==== DFFR ====
* Created by KLayout
* pin CK
* pin D
* pin RST
* pin QB
* pin Q
* pin VDD
* pin GND
* pin CK
* pin D
* pin RST
* pin QB
* pin Q
* pin VDD
* pin GND
.SUBCKT DFFR CK D RST QB Q VDD GND
* device instance $1 r0 *1 82,46.1 PMOS
M$1 QB \$11 VDD VDD PMOS L=1u W=10.2u AS=28.56p AD=15.3p PS=26u PD=13.2u
* device instance $2 r0 *1 86,46.1 PMOS
M$2 VDD QB Q VDD PMOS L=1u W=10.2u AS=15.3p AD=28.56p PS=13.2u PD=26u
* device instance $3 r0 *1 57.2,46.1 PMOS
M$3 VDD \$8 \$22 VDD PMOS L=1u W=10.2u AS=28.56p AD=7.14p PS=26u PD=11.6u
* device instance $4 r0 *1 59.6,46.1 PMOS
M$4 \$22 \$5 \$10 VDD PMOS L=1u W=10.2u AS=7.14p AD=15.3p PS=11.6u PD=13.2u
* device instance $5 r0 *1 63.6,46.1 PMOS
M$5 \$10 \$4 \$23 VDD PMOS L=1u W=10.2u AS=15.3p AD=7.14p PS=13.2u PD=11.6u
* device instance $6 r0 *1 66,46.1 PMOS
M$6 \$23 \$11 VDD VDD PMOS L=1u W=10.2u AS=7.14p AD=15.3p PS=11.6u PD=13.2u
* device instance $7 r0 *1 70,46.1 PMOS
M$7 VDD \$10 \$24 VDD PMOS L=1u W=10.2u AS=15.3p AD=15.3p PS=13.2u PD=13.2u
* device instance $8 r0 *1 74,46.1 PMOS
M$8 \$24 RST \$11 VDD PMOS L=1u W=10.2u AS=15.3p AD=28.56p PS=13.2u PD=26u
* device instance $9 r0 *1 24.4,46.1 PMOS
M$9 \$5 \$4 VDD VDD PMOS L=1u W=10.2u AS=28.56p AD=15.3p PS=26u PD=13.2u
* device instance $10 r0 *1 28.4,46.1 PMOS
M$10 VDD D \$19 VDD PMOS L=1u W=10.2u AS=15.3p AD=7.14p PS=13.2u PD=11.6u
* device instance $11 r0 *1 30.8,46.1 PMOS
M$11 \$19 \$4 \$7 VDD PMOS L=1u W=10.2u AS=7.14p AD=28.56p PS=11.6u PD=26u
* device instance $12 r0 *1 38.8,46.1 PMOS
M$12 \$7 \$5 \$20 VDD PMOS L=1u W=10.2u AS=28.56p AD=7.14p PS=26u PD=11.6u
* device instance $13 r0 *1 41.2,46.1 PMOS
M$13 \$20 \$8 VDD VDD PMOS L=1u W=10.2u AS=7.14p AD=15.3p PS=11.6u PD=13.2u
* device instance $14 r0 *1 45.2,46.1 PMOS
M$14 VDD \$7 \$21 VDD PMOS L=1u W=10.2u AS=15.3p AD=15.3p PS=13.2u PD=13.2u
* device instance $15 r0 *1 49.2,46.1 PMOS
M$15 \$21 RST \$8 VDD PMOS L=1u W=10.2u AS=15.3p AD=28.56p PS=13.2u PD=26u
* device instance $16 r0 *1 12.4,46.1 PMOS
M$16 \$2 CK VDD VDD PMOS L=1u W=10.2u AS=28.56p AD=15.3p PS=26u PD=13.2u
* device instance $17 r0 *1 16.4,46.1 PMOS
M$17 VDD \$2 \$4 VDD PMOS L=1u W=10.2u AS=15.3p AD=28.56p PS=13.2u PD=26u
* device instance $18 r0 *1 82,8.1 NMOS
M$18 QB \$11 GND GND NMOS L=1u W=3.4u AS=9.52p AD=5.1p PS=12.4u PD=6.4u
* device instance $19 r0 *1 86,8.1 NMOS
M$19 GND QB Q GND NMOS L=1u W=3.4u AS=5.1p AD=9.52p PS=6.4u PD=12.4u
* device instance $20 r0 *1 57.2,8.1 NMOS
M$20 GND \$8 \$16 GND NMOS L=1u W=3.4u AS=9.52p AD=2.38p PS=12.4u PD=4.8u
* device instance $21 r0 *1 59.6,8.1 NMOS
M$21 \$16 \$4 \$10 GND NMOS L=1u W=3.4u AS=2.38p AD=5.1p PS=4.8u PD=6.4u
* device instance $22 r0 *1 63.6,8.1 NMOS
M$22 \$10 \$5 \$17 GND NMOS L=1u W=3.4u AS=5.1p AD=2.38p PS=6.4u PD=4.8u
* device instance $23 r0 *1 66,8.1 NMOS
M$23 \$17 \$11 GND GND NMOS L=1u W=3.4u AS=2.38p AD=5.1p PS=4.8u PD=6.4u
* device instance $24 r0 *1 70,8.1 NMOS
M$24 GND \$10 \$11 GND NMOS L=1u W=3.4u AS=5.1p AD=5.1p PS=6.4u PD=6.4u
* device instance $25 r0 *1 74,8.1 NMOS
M$25 \$11 RST GND GND NMOS L=1u W=3.4u AS=5.1p AD=9.52p PS=6.4u PD=12.4u
* device instance $26 r0 *1 38.8,8.1 NMOS
M$26 \$7 \$4 \$15 GND NMOS L=1u W=3.4u AS=9.52p AD=2.38p PS=12.4u PD=4.8u
* device instance $27 r0 *1 41.2,8.1 NMOS
M$27 \$15 \$8 GND GND NMOS L=1u W=3.4u AS=2.38p AD=5.1p PS=4.8u PD=6.4u
* device instance $28 r0 *1 45.2,8.1 NMOS
M$28 GND \$7 \$8 GND NMOS L=1u W=3.4u AS=5.1p AD=5.1p PS=6.4u PD=6.4u
* device instance $29 r0 *1 49.2,8.1 NMOS
M$29 \$8 RST GND GND NMOS L=1u W=3.4u AS=5.1p AD=9.52p PS=6.4u PD=12.4u
* device instance $30 r0 *1 24.4,8.1 NMOS
M$30 \$5 \$4 GND GND NMOS L=1u W=3.4u AS=9.52p AD=5.1p PS=12.4u PD=6.4u
* device instance $31 r0 *1 28.4,8.1 NMOS
M$31 GND D \$14 GND NMOS L=1u W=3.4u AS=5.1p AD=2.38p PS=6.4u PD=4.8u
* device instance $32 r0 *1 30.8,8.1 NMOS
M$32 \$14 \$5 \$7 GND NMOS L=1u W=3.4u AS=2.38p AD=9.52p PS=4.8u PD=12.4u
* device instance $33 r0 *1 12.4,8.1 NMOS
M$33 \$2 CK GND GND NMOS L=1u W=3.4u AS=9.52p AD=5.1p PS=12.4u PD=6.4u
* device instance $34 r0 *1 16.4,8.1 NMOS
M$34 GND \$2 \$4 GND NMOS L=1u W=3.4u AS=5.1p AD=9.52p PS=6.4u PD=12.4u
.ENDS DFFR
* ==== DFFS ====
* Created by KLayout
* pin CK
* pin D
* pin QB
* pin Q
* pin SET
* pin VDD
* pin GND
* pin CK
* pin D
* pin QB
* pin Q
* pin SET
* pin VDD
* pin GND
.SUBCKT DFFS CK D QB Q SET VDD GND
* device instance $1 r0 *1 82,46.1 PMOS
M$1 QB \$10 VDD VDD PMOS L=1u W=10.2u AS=28.56p AD=15.3p PS=26u PD=13.2u
* device instance $2 r0 *1 86,46.1 PMOS
M$2 VDD QB Q VDD PMOS L=1u W=10.2u AS=15.3p AD=28.56p PS=13.2u PD=26u
* device instance $3 r0 *1 57.2,46.1 PMOS
M$3 VDD \$8 \$23 VDD PMOS L=1u W=10.2u AS=28.56p AD=7.14p PS=26u PD=11.6u
* device instance $4 r0 *1 59.6,46.1 PMOS
M$4 \$23 \$5 \$9 VDD PMOS L=1u W=10.2u AS=7.14p AD=15.3p PS=11.6u PD=13.2u
* device instance $5 r0 *1 63.6,46.1 PMOS
M$5 \$9 \$4 \$24 VDD PMOS L=1u W=10.2u AS=15.3p AD=7.14p PS=13.2u PD=11.6u
* device instance $6 r0 *1 66,46.1 PMOS
M$6 \$24 \$10 VDD VDD PMOS L=1u W=10.2u AS=7.14p AD=15.3p PS=11.6u PD=13.2u
* device instance $7 r0 *1 70,46.1 PMOS
M$7 VDD \$9 \$10 VDD PMOS L=1u W=10.2u AS=15.3p AD=15.3p PS=13.2u PD=13.2u
* device instance $8 r0 *1 74,46.1 PMOS
M$8 \$10 SET VDD VDD PMOS L=1u W=10.2u AS=15.3p AD=28.56p PS=13.2u PD=26u
* device instance $9 r0 *1 38.8,46.1 PMOS
M$9 \$7 \$5 \$22 VDD PMOS L=1u W=10.2u AS=28.56p AD=7.14p PS=26u PD=11.6u
* device instance $10 r0 *1 41.2,46.1 PMOS
M$10 \$22 \$8 VDD VDD PMOS L=1u W=10.2u AS=7.14p AD=15.3p PS=11.6u PD=13.2u
* device instance $11 r0 *1 45.2,46.1 PMOS
M$11 VDD \$7 \$8 VDD PMOS L=1u W=10.2u AS=15.3p AD=15.3p PS=13.2u PD=13.2u
* device instance $12 r0 *1 49.2,46.1 PMOS
M$12 \$8 SET VDD VDD PMOS L=1u W=10.2u AS=15.3p AD=28.56p PS=13.2u PD=26u
* device instance $13 r0 *1 12.4,46.1 PMOS
M$13 \$2 CK VDD VDD PMOS L=1u W=10.2u AS=28.56p AD=15.3p PS=26u PD=13.2u
* device instance $14 r0 *1 16.4,46.1 PMOS
M$14 VDD \$2 \$4 VDD PMOS L=1u W=10.2u AS=15.3p AD=28.56p PS=13.2u PD=26u
* device instance $15 r0 *1 24.4,46.1 PMOS
M$15 \$5 \$4 VDD VDD PMOS L=1u W=10.2u AS=28.56p AD=15.3p PS=26u PD=13.2u
* device instance $16 r0 *1 28.4,46.1 PMOS
M$16 VDD D \$21 VDD PMOS L=1u W=10.2u AS=15.3p AD=7.14p PS=13.2u PD=11.6u
* device instance $17 r0 *1 30.8,46.1 PMOS
M$17 \$21 \$4 \$7 VDD PMOS L=1u W=10.2u AS=7.14p AD=28.56p PS=11.6u PD=26u
* device instance $18 r0 *1 78.8,8.1 NMOS
M$18 QB \$10 GND GND NMOS L=1u W=3.4u AS=9.52p AD=5.1p PS=12.4u PD=6.4u
* device instance $19 r0 *1 82.8,8.1 NMOS
M$19 GND QB Q GND NMOS L=1u W=3.4u AS=5.1p AD=9.52p PS=6.4u PD=12.4u
* device instance $20 r0 *1 55.6,8.1 NMOS
M$20 GND \$8 \$17 GND NMOS L=1u W=3.4u AS=9.52p AD=2.38p PS=12.4u PD=4.8u
* device instance $21 r0 *1 58,8.1 NMOS
M$21 \$17 \$4 \$9 GND NMOS L=1u W=3.4u AS=2.38p AD=5.1p PS=4.8u PD=6.4u
* device instance $22 r0 *1 62,8.1 NMOS
M$22 \$9 \$5 \$18 GND NMOS L=1u W=3.4u AS=5.1p AD=2.38p PS=6.4u PD=4.8u
* device instance $23 r0 *1 64.4,8.1 NMOS
M$23 \$18 \$10 GND GND NMOS L=1u W=3.4u AS=2.38p AD=5.1p PS=4.8u PD=6.4u
* device instance $24 r0 *1 68.4,8.1 NMOS
M$24 GND \$9 \$15 GND NMOS L=1u W=3.4u AS=5.1p AD=2.38p PS=6.4u PD=4.8u
* device instance $25 r0 *1 70.8,8.1 NMOS
M$25 \$15 SET \$10 GND NMOS L=1u W=3.4u AS=2.38p AD=9.52p PS=4.8u PD=12.4u
* device instance $26 r0 *1 38.8,8.1 NMOS
M$26 \$7 \$4 \$14 GND NMOS L=1u W=3.4u AS=9.52p AD=2.38p PS=12.4u PD=4.8u
* device instance $27 r0 *1 41.2,8.1 NMOS
M$27 \$14 \$8 GND GND NMOS L=1u W=3.4u AS=2.38p AD=5.1p PS=4.8u PD=6.4u
* device instance $28 r0 *1 45.2,8.1 NMOS
M$28 GND \$7 \$16 GND NMOS L=1u W=3.4u AS=5.1p AD=2.38p PS=6.4u PD=4.8u
* device instance $29 r0 *1 47.6,8.1 NMOS
M$29 \$16 SET \$8 GND NMOS L=1u W=3.4u AS=2.38p AD=9.52p PS=4.8u PD=12.4u
* device instance $30 r0 *1 24.4,8.1 NMOS
M$30 \$5 \$4 GND GND NMOS L=1u W=3.4u AS=9.52p AD=5.1p PS=12.4u PD=6.4u
* device instance $31 r0 *1 28.4,8.1 NMOS
M$31 GND D \$13 GND NMOS L=1u W=3.4u AS=5.1p AD=2.38p PS=6.4u PD=4.8u
* device instance $32 r0 *1 30.8,8.1 NMOS
M$32 \$13 \$5 \$7 GND NMOS L=1u W=3.4u AS=2.38p AD=9.52p PS=4.8u PD=12.4u
* device instance $33 r0 *1 12.4,8.1 NMOS
M$33 \$2 CK GND GND NMOS L=1u W=3.4u AS=9.52p AD=5.1p PS=12.4u PD=6.4u
* device instance $34 r0 *1 16.4,8.1 NMOS
M$34 GND \$2 \$4 GND NMOS L=1u W=3.4u AS=5.1p AD=9.52p PS=6.4u PD=12.4u
.ENDS DFFS
* ==== INV_X1 ====
* Created by KLayout

* cell INV_X1
* pin VDD
* pin A
* pin Y
* pin GND
.SUBCKT INV_X1 VDD A Y GND
* device instance $1 r0 *1 6.1,44.8 PMOS
M$1 Y A VDD VDD PMOS L=1U W=10.2U AS=28.56P AD=28.56P PS=26U PD=26U
* device instance $2 r0 *1 6.1,6.8 NMOS
M$2 Y A GND GND NMOS L=1U W=3.4U AS=9.52P AD=9.52P PS=12.4U PD=12.4U
.ENDS INV_X1

* ==== INV_X12 ====
* Created by KLayout

* cell INV_X12
* pin A
* pin Y
* pin VDD
* pin GND
.SUBCKT INV_X12 A Y VDD GND
* device instance $1 r0 *1 6.1,44.8 PMOS
M$1 Y A VDD VDD PMOS L=1U W=10.2U AS=28.56P AD=15.3P PS=26U PD=13.2U
* device instance $2 r0 *1 10.1,44.8 PMOS
M$2 VDD A Y VDD PMOS L=1U W=10.2U AS=15.3P AD=15.3P PS=13.2U PD=13.2U
* device instance $3 r0 *1 14.1,44.8 PMOS
M$3 Y A VDD VDD PMOS L=1U W=10.2U AS=15.3P AD=15.3P PS=13.2U PD=13.2U
* device instance $4 r0 *1 18.1,44.8 PMOS
M$4 VDD A Y VDD PMOS L=1U W=10.2U AS=15.3P AD=15.3P PS=13.2U PD=13.2U
* device instance $5 r0 *1 22.1,44.8 PMOS
M$5 Y A VDD VDD PMOS L=1U W=10.2U AS=15.3P AD=15.3P PS=13.2U PD=13.2U
* device instance $6 r0 *1 26.1,44.8 PMOS
M$6 VDD A Y VDD PMOS L=1U W=10.2U AS=15.3P AD=15.3P PS=13.2U PD=13.2U
* device instance $7 r0 *1 30.1,44.8 PMOS
M$7 Y A VDD VDD PMOS L=1U W=10.2U AS=15.3P AD=15.3P PS=13.2U PD=13.2U
* device instance $8 r0 *1 34.1,44.8 PMOS
M$8 VDD A Y VDD PMOS L=1U W=10.2U AS=15.3P AD=15.3P PS=13.2U PD=13.2U
* device instance $9 r0 *1 38.1,44.8 PMOS
M$9 Y A VDD VDD PMOS L=1U W=10.2U AS=15.3P AD=15.3P PS=13.2U PD=13.2U
* device instance $10 r0 *1 42.1,44.8 PMOS
M$10 VDD A Y VDD PMOS L=1U W=10.2U AS=15.3P AD=15.3P PS=13.2U PD=13.2U
* device instance $11 r0 *1 46.1,44.8 PMOS
M$11 Y A VDD VDD PMOS L=1U W=10.2U AS=15.3P AD=15.3P PS=13.2U PD=13.2U
* device instance $12 r0 *1 50.1,44.8 PMOS
M$12 VDD A Y VDD PMOS L=1U W=10.2U AS=15.3P AD=28.56P PS=13.2U PD=26U
* device instance $13 r0 *1 6.1,6.8 NMOS
M$13 Y A GND GND NMOS L=1U W=3.4U AS=9.52P AD=5.1P PS=12.4U PD=6.4U
* device instance $14 r0 *1 10.1,6.8 NMOS
M$14 GND A Y GND NMOS L=1U W=3.4U AS=5.1P AD=5.1P PS=6.4U PD=6.4U
* device instance $15 r0 *1 14.1,6.8 NMOS
M$15 Y A GND GND NMOS L=1U W=3.4U AS=5.1P AD=5.1P PS=6.4U PD=6.4U
* device instance $16 r0 *1 18.1,6.8 NMOS
M$16 GND A Y GND NMOS L=1U W=3.4U AS=5.1P AD=5.1P PS=6.4U PD=6.4U
* device instance $17 r0 *1 22.1,6.8 NMOS
M$17 Y A GND GND NMOS L=1U W=3.4U AS=5.1P AD=5.1P PS=6.4U PD=6.4U
* device instance $18 r0 *1 26.1,6.8 NMOS
M$18 GND A Y GND NMOS L=1U W=3.4U AS=5.1P AD=5.1P PS=6.4U PD=6.4U
* device instance $19 r0 *1 30.1,6.8 NMOS
M$19 Y A GND GND NMOS L=1U W=3.4U AS=5.1P AD=5.1P PS=6.4U PD=6.4U
* device instance $20 r0 *1 34.1,6.8 NMOS
M$20 GND A Y GND NMOS L=1U W=3.4U AS=5.1P AD=5.1P PS=6.4U PD=6.4U
* device instance $21 r0 *1 38.1,6.8 NMOS
M$21 Y A GND GND NMOS L=1U W=3.4U AS=5.1P AD=5.1P PS=6.4U PD=6.4U
* device instance $22 r0 *1 42.1,6.8 NMOS
M$22 GND A Y GND NMOS L=1U W=3.4U AS=5.1P AD=5.1P PS=6.4U PD=6.4U
* device instance $23 r0 *1 46.1,6.8 NMOS
M$23 Y A GND GND NMOS L=1U W=3.4U AS=5.1P AD=5.1P PS=6.4U PD=6.4U
* device instance $24 r0 *1 50.1,6.8 NMOS
M$24 GND A Y GND NMOS L=1U W=3.4U AS=5.1P AD=9.52P PS=6.4U PD=12.4U
.ENDS INV_X12

* ==== INV_X16 ====
* Created by KLayout

* cell INV_X16
* pin Y
* pin A
* pin VDD
* pin GND
.SUBCKT INV_X16 Y A VDD GND
* device instance $1 r0 *1 6.1,44.8 PMOS
M$1 Y A VDD VDD PMOS L=1U W=10.2U AS=28.56P AD=15.3P PS=26U PD=13.2U
* device instance $2 r0 *1 10.1,44.8 PMOS
M$2 VDD A Y VDD PMOS L=1U W=10.2U AS=15.3P AD=15.3P PS=13.2U PD=13.2U
* device instance $3 r0 *1 14.1,44.8 PMOS
M$3 Y A VDD VDD PMOS L=1U W=10.2U AS=15.3P AD=15.3P PS=13.2U PD=13.2U
* device instance $4 r0 *1 18.1,44.8 PMOS
M$4 VDD A Y VDD PMOS L=1U W=10.2U AS=15.3P AD=15.3P PS=13.2U PD=13.2U
* device instance $5 r0 *1 22.1,44.8 PMOS
M$5 Y A VDD VDD PMOS L=1U W=10.2U AS=15.3P AD=15.3P PS=13.2U PD=13.2U
* device instance $6 r0 *1 26.1,44.8 PMOS
M$6 VDD A Y VDD PMOS L=1U W=10.2U AS=15.3P AD=15.3P PS=13.2U PD=13.2U
* device instance $7 r0 *1 30.1,44.8 PMOS
M$7 Y A VDD VDD PMOS L=1U W=10.2U AS=15.3P AD=15.3P PS=13.2U PD=13.2U
* device instance $8 r0 *1 34.1,44.8 PMOS
M$8 VDD A Y VDD PMOS L=1U W=10.2U AS=15.3P AD=15.3P PS=13.2U PD=13.2U
* device instance $9 r0 *1 38.1,44.8 PMOS
M$9 Y A VDD VDD PMOS L=1U W=10.2U AS=15.3P AD=15.3P PS=13.2U PD=13.2U
* device instance $10 r0 *1 42.1,44.8 PMOS
M$10 VDD A Y VDD PMOS L=1U W=10.2U AS=15.3P AD=15.3P PS=13.2U PD=13.2U
* device instance $11 r0 *1 46.1,44.8 PMOS
M$11 Y A VDD VDD PMOS L=1U W=10.2U AS=15.3P AD=15.3P PS=13.2U PD=13.2U
* device instance $12 r0 *1 50.1,44.8 PMOS
M$12 VDD A Y VDD PMOS L=1U W=10.2U AS=15.3P AD=15.3P PS=13.2U PD=13.2U
* device instance $13 r0 *1 54.1,44.8 PMOS
M$13 Y A VDD VDD PMOS L=1U W=10.2U AS=15.3P AD=15.3P PS=13.2U PD=13.2U
* device instance $14 r0 *1 58.1,44.8 PMOS
M$14 VDD A Y VDD PMOS L=1U W=10.2U AS=15.3P AD=15.3P PS=13.2U PD=13.2U
* device instance $15 r0 *1 62.1,44.8 PMOS
M$15 Y A VDD VDD PMOS L=1U W=10.2U AS=15.3P AD=15.3P PS=13.2U PD=13.2U
* device instance $16 r0 *1 66.1,44.8 PMOS
M$16 VDD A Y VDD PMOS L=1U W=10.2U AS=15.3P AD=28.56P PS=13.2U PD=26U
* device instance $17 r0 *1 6.1,6.8 NMOS
M$17 Y A GND GND NMOS L=1U W=3.4U AS=9.52P AD=5.1P PS=12.4U PD=6.4U
* device instance $18 r0 *1 10.1,6.8 NMOS
M$18 GND A Y GND NMOS L=1U W=3.4U AS=5.1P AD=5.1P PS=6.4U PD=6.4U
* device instance $19 r0 *1 14.1,6.8 NMOS
M$19 Y A GND GND NMOS L=1U W=3.4U AS=5.1P AD=5.1P PS=6.4U PD=6.4U
* device instance $20 r0 *1 18.1,6.8 NMOS
M$20 GND A Y GND NMOS L=1U W=3.4U AS=5.1P AD=5.1P PS=6.4U PD=6.4U
* device instance $21 r0 *1 22.1,6.8 NMOS
M$21 Y A GND GND NMOS L=1U W=3.4U AS=5.1P AD=5.1P PS=6.4U PD=6.4U
* device instance $22 r0 *1 26.1,6.8 NMOS
M$22 GND A Y GND NMOS L=1U W=3.4U AS=5.1P AD=5.1P PS=6.4U PD=6.4U
* device instance $23 r0 *1 30.1,6.8 NMOS
M$23 Y A GND GND NMOS L=1U W=3.4U AS=5.1P AD=5.1P PS=6.4U PD=6.4U
* device instance $24 r0 *1 34.1,6.8 NMOS
M$24 GND A Y GND NMOS L=1U W=3.4U AS=5.1P AD=5.1P PS=6.4U PD=6.4U
* device instance $25 r0 *1 38.1,6.8 NMOS
M$25 Y A GND GND NMOS L=1U W=3.4U AS=5.1P AD=5.1P PS=6.4U PD=6.4U
* device instance $26 r0 *1 42.1,6.8 NMOS
M$26 GND A Y GND NMOS L=1U W=3.4U AS=5.1P AD=5.1P PS=6.4U PD=6.4U
* device instance $27 r0 *1 46.1,6.8 NMOS
M$27 Y A GND GND NMOS L=1U W=3.4U AS=5.1P AD=5.1P PS=6.4U PD=6.4U
* device instance $28 r0 *1 50.1,6.8 NMOS
M$28 GND A Y GND NMOS L=1U W=3.4U AS=5.1P AD=5.1P PS=6.4U PD=6.4U
* device instance $29 r0 *1 54.1,6.8 NMOS
M$29 Y A GND GND NMOS L=1U W=3.4U AS=5.1P AD=5.1P PS=6.4U PD=6.4U
* device instance $30 r0 *1 58.1,6.8 NMOS
M$30 GND A Y GND NMOS L=1U W=3.4U AS=5.1P AD=5.1P PS=6.4U PD=6.4U
* device instance $31 r0 *1 62.1,6.8 NMOS
M$31 Y A GND GND NMOS L=1U W=3.4U AS=5.1P AD=5.1P PS=6.4U PD=6.4U
* device instance $32 r0 *1 66.1,6.8 NMOS
M$32 GND A Y GND NMOS L=1U W=3.4U AS=5.1P AD=9.52P PS=6.4U PD=12.4U
.ENDS INV_X16

* ==== INV_X2 ====
* Created by KLayout

* cell INV_X2
* pin A
* pin VDD
* pin Y
* pin GND
.SUBCKT INV_X2 A VDD Y GND
* device instance $1 r0 *1 6.1,44.8 PMOS
M$1 Y A VDD VDD PMOS L=1U W=10.2U AS=28.56P AD=15.3P PS=26U PD=13.2U
* device instance $2 r0 *1 10.1,44.8 PMOS
M$2 VDD A Y VDD PMOS L=1U W=10.2U AS=15.3P AD=28.56P PS=13.2U PD=26U
* device instance $3 r0 *1 6.1,6.8 NMOS
M$3 Y A GND GND NMOS L=1U W=3.4U AS=9.52P AD=5.1P PS=12.4U PD=6.4U
* device instance $4 r0 *1 10.1,6.8 NMOS
M$4 GND A Y GND NMOS L=1U W=3.4U AS=5.1P AD=9.52P PS=6.4U PD=12.4U
.ENDS INV_X2

* ==== INV_X4 ====
* Created by KLayout

* cell INV_X4
* pin A
* pin Y
* pin VDD
* pin GND
.SUBCKT INV_X4 A Y VDD GND
* device instance $1 r0 *1 6.1,44.8 PMOS
M$1 Y A VDD VDD PMOS L=1U W=10.2U AS=28.56P AD=15.3P PS=26U PD=13.2U
* device instance $2 r0 *1 10.1,44.8 PMOS
M$2 VDD A Y VDD PMOS L=1U W=10.2U AS=15.3P AD=15.3P PS=13.2U PD=13.2U
* device instance $3 r0 *1 14.1,44.8 PMOS
M$3 Y A VDD VDD PMOS L=1U W=10.2U AS=15.3P AD=15.3P PS=13.2U PD=13.2U
* device instance $4 r0 *1 18.1,44.8 PMOS
M$4 VDD A Y VDD PMOS L=1U W=10.2U AS=15.3P AD=28.56P PS=13.2U PD=26U
* device instance $5 r0 *1 6.1,6.8 NMOS
M$5 Y A GND GND NMOS L=1U W=3.4U AS=9.52P AD=5.1P PS=12.4U PD=6.4U
* device instance $6 r0 *1 10.1,6.8 NMOS
M$6 GND A Y GND NMOS L=1U W=3.4U AS=5.1P AD=5.1P PS=6.4U PD=6.4U
* device instance $7 r0 *1 14.1,6.8 NMOS
M$7 Y A GND GND NMOS L=1U W=3.4U AS=5.1P AD=5.1P PS=6.4U PD=6.4U
* device instance $8 r0 *1 18.1,6.8 NMOS
M$8 GND A Y GND NMOS L=1U W=3.4U AS=5.1P AD=9.52P PS=6.4U PD=12.4U
.ENDS INV_X4

* ==== INV_X8 ====
* Created by KLayout

* cell INV_X8
* pin A
* pin Y
* pin VDD
* pin GND
.SUBCKT INV_X8 A Y VDD GND
* device instance $1 r0 *1 6.1,44.8 PMOS
M$1 Y A VDD VDD PMOS L=1U W=10.2U AS=28.56P AD=15.3P PS=26U PD=13.2U
* device instance $2 r0 *1 10.1,44.8 PMOS
M$2 VDD A Y VDD PMOS L=1U W=10.2U AS=15.3P AD=15.3P PS=13.2U PD=13.2U
* device instance $3 r0 *1 14.1,44.8 PMOS
M$3 Y A VDD VDD PMOS L=1U W=10.2U AS=15.3P AD=15.3P PS=13.2U PD=13.2U
* device instance $4 r0 *1 18.1,44.8 PMOS
M$4 VDD A Y VDD PMOS L=1U W=10.2U AS=15.3P AD=15.3P PS=13.2U PD=13.2U
* device instance $5 r0 *1 22.1,44.8 PMOS
M$5 Y A VDD VDD PMOS L=1U W=10.2U AS=15.3P AD=15.3P PS=13.2U PD=13.2U
* device instance $6 r0 *1 26.1,44.8 PMOS
M$6 VDD A Y VDD PMOS L=1U W=10.2U AS=15.3P AD=15.3P PS=13.2U PD=13.2U
* device instance $7 r0 *1 30.1,44.8 PMOS
M$7 Y A VDD VDD PMOS L=1U W=10.2U AS=15.3P AD=15.3P PS=13.2U PD=13.2U
* device instance $8 r0 *1 34.1,44.8 PMOS
M$8 VDD A Y VDD PMOS L=1U W=10.2U AS=15.3P AD=28.56P PS=13.2U PD=26U
* device instance $9 r0 *1 6.1,6.8 NMOS
M$9 Y A GND GND NMOS L=1U W=3.4U AS=9.52P AD=5.1P PS=12.4U PD=6.4U
* device instance $10 r0 *1 10.1,6.8 NMOS
M$10 GND A Y GND NMOS L=1U W=3.4U AS=5.1P AD=5.1P PS=6.4U PD=6.4U
* device instance $11 r0 *1 14.1,6.8 NMOS
M$11 Y A GND GND NMOS L=1U W=3.4U AS=5.1P AD=5.1P PS=6.4U PD=6.4U
* device instance $12 r0 *1 18.1,6.8 NMOS
M$12 GND A Y GND NMOS L=1U W=3.4U AS=5.1P AD=5.1P PS=6.4U PD=6.4U
* device instance $13 r0 *1 22.1,6.8 NMOS
M$13 Y A GND GND NMOS L=1U W=3.4U AS=5.1P AD=5.1P PS=6.4U PD=6.4U
* device instance $14 r0 *1 26.1,6.8 NMOS
M$14 GND A Y GND NMOS L=1U W=3.4U AS=5.1P AD=5.1P PS=6.4U PD=6.4U
* device instance $15 r0 *1 30.1,6.8 NMOS
M$15 Y A GND GND NMOS L=1U W=3.4U AS=5.1P AD=5.1P PS=6.4U PD=6.4U
* device instance $16 r0 *1 34.1,6.8 NMOS
M$16 GND A Y GND NMOS L=1U W=3.4U AS=5.1P AD=9.52P PS=6.4U PD=12.4U
.ENDS INV_X8

* ==== MUX2 ====
* Created by KLayout

* cell MUX2
* pin S
* pin Y
* pin B
* pin A
* pin VDD
* pin GND
.SUBCKT MUX2 S Y B A VDD GND
* device instance $1 r0 *1 38.1,46.5 PMOS
M$1 \$7 S \$5 VDD PMOS L=1U W=6.8U AS=19.04P AD=10.2P PS=19.2U PD=9.8U
* device instance $2 r0 *1 42.1,46.5 PMOS
M$2 VDD A \$7 VDD PMOS L=1U W=6.8U AS=10.2P AD=19.04P PS=9.8U PD=19.2U
* device instance $3 r0 *1 26.1,47.35 PMOS
M$3 Y \$5 VDD VDD PMOS L=1U W=5.1U AS=14.28P AD=7.65P PS=15.8U PD=8.1U
* device instance $4 r0 *1 30.1,47.35 PMOS
M$4 VDD \$5 Y VDD PMOS L=1U W=5.1U AS=7.65P AD=14.28P PS=8.1U PD=15.8U
* device instance $5 r0 *1 6.1,46.5 PMOS
M$5 VDD S \$2 VDD PMOS L=1U W=6.8U AS=19.04P AD=19.04P PS=19.2U PD=19.2U
* device instance $6 r0 *1 14.1,46.5 PMOS
M$6 \$4 \$2 \$5 VDD PMOS L=1U W=6.8U AS=19.04P AD=10.2P PS=19.2U PD=9.8U
* device instance $7 r0 *1 18.1,46.5 PMOS
M$7 VDD B \$4 VDD PMOS L=1U W=6.8U AS=10.2P AD=19.04P PS=9.8U PD=19.2U
* device instance $8 r0 *1 34.9,6.8 NMOS
M$8 \$5 \$2 \$7 GND NMOS L=1U W=3.4U AS=9.52P AD=5.1P PS=12.4U PD=6.4U
* device instance $9 r0 *1 38.9,6.8 NMOS
M$9 \$7 \$2 \$5 GND NMOS L=1U W=3.4U AS=5.1P AD=5.1P PS=6.4U PD=6.4U
* device instance $10 r0 *1 42.9,6.8 NMOS
M$10 GND A \$7 GND NMOS L=1U W=3.4U AS=5.1P AD=9.52P PS=6.4U PD=12.4U
* device instance $11 r0 *1 14.1,6.8 NMOS
M$11 \$5 S \$4 GND NMOS L=1U W=3.4U AS=9.52P AD=5.1P PS=12.4U PD=6.4U
* device instance $12 r0 *1 18.1,6.8 NMOS
M$12 \$4 S \$5 GND NMOS L=1U W=3.4U AS=5.1P AD=5.1P PS=6.4U PD=6.4U
* device instance $13 r0 *1 22.1,6.8 NMOS
M$13 GND B \$4 GND NMOS L=1U W=3.4U AS=5.1P AD=5.1P PS=6.4U PD=6.4U
* device instance $14 r0 *1 26.1,6.8 NMOS
M$14 Y \$5 GND GND NMOS L=1U W=3.4U AS=5.1P AD=9.52P PS=6.4U PD=12.4U
* device instance $15 r0 *1 6.1,6.8 NMOS
M$15 GND S \$2 GND NMOS L=1U W=3.4U AS=9.52P AD=9.52P PS=12.4U PD=12.4U
.ENDS MUX2

* ==== NAND2 ====
* Created by KLayout

* cell NAND2
* pin VDD
* pin A
* pin B
* pin Y
* pin GND
.SUBCKT NAND2 VDD A B Y GND
* device instance $1 r0 *1 6.1,44.8 PMOS
M$1 Y A VDD VDD PMOS L=1U W=10.2U AS=28.56P AD=15.3P PS=26U PD=13.2U
* device instance $2 r0 *1 10.1,44.8 PMOS
M$2 VDD B Y VDD PMOS L=1U W=10.2U AS=15.3P AD=28.56P PS=13.2U PD=26U
* device instance $3 r0 *1 6.1,6.8 NMOS
M$3 \$6 A GND GND NMOS L=1U W=3.4U AS=9.52P AD=5.1P PS=12.4U PD=6.4U
* device instance $4 r0 *1 10.1,6.8 NMOS
M$4 Y B \$6 GND NMOS L=1U W=3.4U AS=5.1P AD=9.52P PS=6.4U PD=12.4U
.ENDS NAND2

* ==== NAND3 ====
* Created by KLayout
* pin A
* pin Y
* pin B
* pin C
* pin VDD
* pin GND
* pin Y
* pin A
* pin B
* pin C
* pin VDD
* pin GND
.SUBCKT NAND3 A Y B C VDD GND
* device instance $1 r0 *1 12.4,46.1 PMOS
M$1 VDD A Y VDD PMOS L=1u W=10.2u AS=28.56p AD=15.3p PS=26u PD=13.2u
* device instance $2 r0 *1 16.4,46.1 PMOS
M$2 Y B VDD VDD PMOS L=1u W=10.2u AS=15.3p AD=15.3p PS=13.2u PD=13.2u
* device instance $3 r0 *1 20.4,46.1 PMOS
M$3 VDD C Y VDD PMOS L=1u W=10.2u AS=15.3p AD=28.56p PS=13.2u PD=26u
* device instance $4 r0 *1 12.4,8.1 NMOS
M$4 Y A \$3 GND NMOS L=1u W=3.4u AS=9.52p AD=5.1p PS=12.4u PD=6.4u
* device instance $5 r0 *1 16.4,8.1 NMOS
M$5 \$3 B \$4 GND NMOS L=1u W=3.4u AS=5.1p AD=5.1p PS=6.4u PD=6.4u
* device instance $6 r0 *1 20.4,8.1 NMOS
M$6 \$4 C GND GND NMOS L=1u W=3.4u AS=5.1p AD=9.52p PS=6.4u PD=12.4u
.ENDS NAND3
* ==== NAND4 ====
* Created by KLayout

* cell NAND4
* pin A
* pin B
* pin Y
* pin C
* pin D
* pin VDD
* pin GND
.SUBCKT NAND4 A B Y C D VDD GND
* device instance $1 r0 *1 6.1,44.8 PMOS
M$1 Y A VDD VDD PMOS L=1U W=10.2U AS=28.56P AD=15.3P PS=26U PD=13.2U
* device instance $2 r0 *1 10.1,44.8 PMOS
M$2 VDD B Y VDD PMOS L=1U W=10.2U AS=15.3P AD=15.3P PS=13.2U PD=13.2U
* device instance $3 r0 *1 14.1,44.8 PMOS
M$3 Y C VDD VDD PMOS L=1U W=10.2U AS=15.3P AD=15.3P PS=13.2U PD=13.2U
* device instance $4 r0 *1 18.1,44.8 PMOS
M$4 VDD D Y VDD PMOS L=1U W=10.2U AS=15.3P AD=28.56P PS=13.2U PD=26U
* device instance $5 r0 *1 6.1,6.8 NMOS
M$5 \$4 A GND GND NMOS L=1U W=3.4U AS=9.52P AD=5.1P PS=12.4U PD=6.4U
* device instance $6 r0 *1 10.1,6.8 NMOS
M$6 \$5 B \$4 GND NMOS L=1U W=3.4U AS=5.1P AD=5.1P PS=6.4U PD=6.4U
* device instance $7 r0 *1 14.1,6.8 NMOS
M$7 \$6 C \$5 GND NMOS L=1U W=3.4U AS=5.1P AD=5.1P PS=6.4U PD=6.4U
* device instance $8 r0 *1 18.1,6.8 NMOS
M$8 Y D \$6 GND NMOS L=1U W=3.4U AS=5.1P AD=9.52P PS=6.4U PD=12.4U
.ENDS NAND4

* ==== NOR2 ====
* Created by KLayout

* cell NOR2
* pin A
* pin B
* pin VDD
* pin Y
* pin VSS
.SUBCKT NOR2 A B VDD Y GND
* device instance $1 r0 *1 6.1,44.8 PMOS
M$1 \$5 A VDD VDD PMOS L=1U W=10.2U AS=28.56P AD=15.3P PS=26U PD=13.2U
* device instance $2 r0 *1 10.1,44.8 PMOS
M$2 Y B \$5 VDD PMOS L=1U W=10.2U AS=15.3P AD=28.56P PS=13.2U PD=26U
* device instance $3 r0 *1 6.1,6.8 NMOS
M$3 Y A GND GND NMOS L=1U W=3.4U AS=9.52P AD=5.1P PS=12.4U PD=6.4U
* device instance $4 r0 *1 10.1,6.8 NMOS
M$4 GND B Y GND NMOS L=1U W=3.4U AS=5.1P AD=9.52P PS=6.4U PD=12.4U
.ENDS NOR2

* ==== NOR3 ====
* Created by KLayout

* cell NOR3
* pin VDD
* pin B
* pin A
* pin C
* pin Y
* pin GND
.SUBCKT NOR3 VDD B A C Y GND
* device instance $1 r0 *1 6.1,44.8 PMOS
M$1 \$7 B VDD VDD PMOS L=1U W=10.2U AS=28.56P AD=15.3P PS=26U PD=13.2U
* device instance $2 r0 *1 10.1,44.8 PMOS
M$2 \$8 A \$7 VDD PMOS L=1U W=10.2U AS=15.3P AD=15.3P PS=13.2U PD=13.2U
* device instance $3 r0 *1 14.1,44.8 PMOS
M$3 Y C \$8 VDD PMOS L=1U W=10.2U AS=15.3P AD=28.56P PS=13.2U PD=26U
* device instance $4 r0 *1 6.1,6.8 NMOS
M$4 Y B GND GND NMOS L=1U W=3.4U AS=9.52P AD=5.1P PS=12.4U PD=6.4U
* device instance $5 r0 *1 10.1,6.8 NMOS
M$5 GND A Y GND NMOS L=1U W=3.4U AS=5.1P AD=5.1P PS=6.4U PD=6.4U
* device instance $6 r0 *1 14.1,6.8 NMOS
M$6 Y C GND GND NMOS L=1U W=3.4U AS=5.1P AD=9.52P PS=6.4U PD=12.4U
.ENDS NOR3

* ==== NOR4 ====
* Created by KLayout

* cell NOR4
* pin Y
* pin A
* pin B
* pin C
* pin D
* pin VDD
* pin GND
.SUBCKT NOR4 Y A B C D VDD GND
* device instance $1 r0 *1 6.1,44.8 PMOS
M$1 \$8 A VDD VDD PMOS L=1U W=10.2U AS=28.56P AD=15.3P PS=26U PD=13.2U
* device instance $2 r0 *1 10.1,44.8 PMOS
M$2 \$9 B \$8 VDD PMOS L=1U W=10.2U AS=15.3P AD=15.3P PS=13.2U PD=13.2U
* device instance $3 r0 *1 14.1,44.8 PMOS
M$3 \$10 C \$9 VDD PMOS L=1U W=10.2U AS=15.3P AD=15.3P PS=13.2U PD=13.2U
* device instance $4 r0 *1 18.1,44.8 PMOS
M$4 Y D \$10 VDD PMOS L=1U W=10.2U AS=15.3P AD=28.56P PS=13.2U PD=26U
* device instance $5 r0 *1 6.1,6.8 NMOS
M$5 Y A GND GND NMOS L=1U W=3.4U AS=9.52P AD=5.1P PS=12.4U PD=6.4U
* device instance $6 r0 *1 10.1,6.8 NMOS
M$6 GND B Y GND NMOS L=1U W=3.4U AS=5.1P AD=5.1P PS=6.4U PD=6.4U
* device instance $7 r0 *1 14.1,6.8 NMOS
M$7 Y C GND GND NMOS L=1U W=3.4U AS=5.1P AD=5.1P PS=6.4U PD=6.4U
* device instance $8 r0 *1 18.1,6.8 NMOS
M$8 GND D Y GND NMOS L=1U W=3.4U AS=5.1P AD=9.52P PS=6.4U PD=12.4U
.ENDS NOR4

* ==== OR2 ====
* Created by KLayout

* cell OR2
* pin VDD
* pin A
* pin B
* pin Y
* pin GND
.SUBCKT OR2 VDD A B Y GND
* device instance $1 r0 *1 6.1,44.8 PMOS
M$1 \$6 A \$5 VDD PMOS L=1U W=10.2U AS=28.56P AD=15.3P PS=26U PD=13.2U
* device instance $2 r0 *1 10.1,44.8 PMOS
M$2 VDD B \$6 VDD PMOS L=1U W=10.2U AS=15.3P AD=15.3P PS=13.2U PD=13.2U
* device instance $3 r0 *1 14.1,44.8 PMOS
M$3 Y \$5 VDD VDD PMOS L=1U W=10.2U AS=15.3P AD=28.56P PS=13.2U PD=26U
* device instance $4 r0 *1 6.1,6.8 NMOS
M$4 \$5 A GND GND NMOS L=1U W=3.4U AS=9.52P AD=5.1P PS=12.4U PD=6.4U
* device instance $5 r0 *1 10.1,6.8 NMOS
M$5 GND B \$5 GND NMOS L=1U W=3.4U AS=5.1P AD=5.1P PS=6.4U PD=6.4U
* device instance $6 r0 *1 14.1,6.8 NMOS
M$6 Y \$5 GND GND NMOS L=1U W=3.4U AS=5.1P AD=9.52P PS=6.4U PD=12.4U
.ENDS OR2

* ==== OR3 ====
* Created by KLayout
* pin A
* pin Y
* pin B
* pin C
* pin VDD
* pin GND
* pin A
* pin Y
* pin B
* pin C
* pin VDD
* pin GND
.SUBCKT OR3 A Y B C VDD GND
* device instance $1 r0 *1 12.4,46.1 PMOS
M$1 \$2 B \$7 VDD PMOS L=1u W=10.2u AS=28.56p AD=15.3p PS=26u PD=13.2u
* device instance $2 r0 *1 16.4,46.1 PMOS
M$2 \$7 A \$8 VDD PMOS L=1u W=10.2u AS=15.3p AD=15.3p PS=13.2u PD=13.2u
* device instance $3 r0 *1 20.4,46.1 PMOS
M$3 \$8 C VDD VDD PMOS L=1u W=10.2u AS=15.3p AD=15.3p PS=13.2u PD=13.2u
* device instance $4 r0 *1 24.4,46.1 PMOS
M$4 VDD \$2 Y VDD PMOS L=1u W=10.2u AS=15.3p AD=28.56p PS=13.2u PD=26u
* device instance $5 r0 *1 12.4,8.1 NMOS
M$5 \$2 B GND GND NMOS L=1u W=3.4u AS=9.52p AD=5.1p PS=12.4u PD=6.4u
* device instance $6 r0 *1 16.4,8.1 NMOS
M$6 GND A \$2 GND NMOS L=1u W=3.4u AS=5.1p AD=5.1p PS=6.4u PD=6.4u
* device instance $7 r0 *1 20.4,8.1 NMOS
M$7 \$2 C GND GND NMOS L=1u W=3.4u AS=5.1p AD=5.1p PS=6.4u PD=6.4u
* device instance $8 r0 *1 24.4,8.1 NMOS
M$8 GND \$2 Y GND NMOS L=1u W=3.4u AS=5.1p AD=9.52p PS=6.4u PD=12.4u
.ENDS OR3
* ==== OR4 ====
* Created by KLayout

* cell OR4
* pin D
* pin C
* pin Y
* pin B
* pin A
* pin VDD
* pin GND
.SUBCKT OR4 D C Y B A VDD GND
* device instance $1 r0 *1 6.1,44.8 PMOS
M$1 \$8 D \$2 VDD PMOS L=1U W=10.2U AS=28.56P AD=15.3P PS=26U PD=13.2U
* device instance $2 r0 *1 10.1,44.8 PMOS
M$2 \$9 C \$8 VDD PMOS L=1U W=10.2U AS=15.3P AD=15.3P PS=13.2U PD=13.2U
* device instance $3 r0 *1 14.1,44.8 PMOS
M$3 \$10 B \$9 VDD PMOS L=1U W=10.2U AS=15.3P AD=15.3P PS=13.2U PD=13.2U
* device instance $4 r0 *1 18.1,44.8 PMOS
M$4 VDD A \$10 VDD PMOS L=1U W=10.2U AS=15.3P AD=15.3P PS=13.2U PD=13.2U
* device instance $5 r0 *1 22.1,44.8 PMOS
M$5 Y \$2 VDD VDD PMOS L=1U W=10.2U AS=15.3P AD=28.56P PS=13.2U PD=26U
* device instance $6 r0 *1 6.1,6.8 NMOS
M$6 \$2 D GND GND NMOS L=1U W=3.4U AS=9.52P AD=5.1P PS=12.4U PD=6.4U
* device instance $7 r0 *1 10.1,6.8 NMOS
M$7 GND C \$2 GND NMOS L=1U W=3.4U AS=5.1P AD=5.1P PS=6.4U PD=6.4U
* device instance $8 r0 *1 14.1,6.8 NMOS
M$8 \$2 B GND GND NMOS L=1U W=3.4U AS=5.1P AD=5.1P PS=6.4U PD=6.4U
* device instance $9 r0 *1 18.1,6.8 NMOS
M$9 GND A \$2 GND NMOS L=1U W=3.4U AS=5.1P AD=5.1P PS=6.4U PD=6.4U
* device instance $10 r0 *1 22.1,6.8 NMOS
M$10 Y \$2 GND GND NMOS L=1U W=3.4U AS=5.1P AD=9.52P PS=6.4U PD=12.4U
.ENDS OR4

* ==== XNOR2 ====
* Created by KLayout

* cell XNOR2
* pin B
* pin Y
* pin A
* pin VDD
* pin GND
.SUBCKT XNOR2 B Y A VDD GND
* device instance $1 r0 *1 18.1,44.8 PMOS
M$1 VDD \$4 Y VDD PMOS L=1U W=10.2U AS=28.56P AD=15.3P PS=26U PD=13.2U
* device instance $2 r0 *1 22.1,44.8 PMOS
M$2 \$9 B VDD VDD PMOS L=1U W=10.2U AS=15.3P AD=15.3P PS=13.2U PD=13.2U
* device instance $3 r0 *1 26.1,44.8 PMOS
M$3 Y A \$9 VDD PMOS L=1U W=10.2U AS=15.3P AD=28.56P PS=13.2U PD=26U
* device instance $4 r0 *1 6.1,44.8 PMOS
M$4 VDD A \$4 VDD PMOS L=1U W=10.2U AS=28.56P AD=15.3P PS=26U PD=13.2U
* device instance $5 r0 *1 10.1,44.8 PMOS
M$5 \$4 B VDD VDD PMOS L=1U W=10.2U AS=15.3P AD=28.56P PS=13.2U PD=26U
* device instance $6 r0 *1 18.1,6.8 NMOS
M$6 \$6 \$4 Y GND NMOS L=1U W=3.4U AS=9.52P AD=5.1P PS=12.4U PD=6.4U
* device instance $7 r0 *1 22.1,6.8 NMOS
M$7 GND B \$6 GND NMOS L=1U W=3.4U AS=5.1P AD=5.1P PS=6.4U PD=6.4U
* device instance $8 r0 *1 26.1,6.8 NMOS
M$8 \$6 A GND GND NMOS L=1U W=3.4U AS=5.1P AD=9.52P PS=6.4U PD=12.4U
* device instance $9 r0 *1 6.1,6.8 NMOS
M$9 \$2 A GND GND NMOS L=1U W=3.4U AS=9.52P AD=5.1P PS=12.4U PD=6.4U
* device instance $10 r0 *1 10.1,6.8 NMOS
M$10 \$4 B \$2 GND NMOS L=1U W=3.4U AS=5.1P AD=9.52P PS=6.4U PD=12.4U
.ENDS XNOR2

* ==== XOR2 ====
* Created by KLayout

* cell XOR2
* pin B
* pin Y
* pin A
* pin VDD
* pin GND
.SUBCKT XOR2 B Y A VDD GND
* device instance $1 r0 *1 18.1,44.8 PMOS
M$1 \$9 \$2 Y VDD PMOS L=1U W=10.2U AS=28.56P AD=15.3P PS=26U PD=13.2U
* device instance $2 r0 *1 22.1,44.8 PMOS
M$2 VDD B \$9 VDD PMOS L=1U W=10.2U AS=15.3P AD=15.3P PS=13.2U PD=13.2U
* device instance $3 r0 *1 26.1,44.8 PMOS
M$3 \$9 A VDD VDD PMOS L=1U W=10.2U AS=15.3P AD=28.56P PS=13.2U PD=26U
* device instance $4 r0 *1 6.1,44.8 PMOS
M$4 \$8 A VDD VDD PMOS L=1U W=10.2U AS=28.56P AD=15.3P PS=26U PD=13.2U
* device instance $5 r0 *1 10.1,44.8 PMOS
M$5 \$2 B \$8 VDD PMOS L=1U W=10.2U AS=15.3P AD=28.56P PS=13.2U PD=26U
* device instance $6 r0 *1 18.1,6.8 NMOS
M$6 GND \$2 Y GND NMOS L=1U W=3.4U AS=9.52P AD=5.1P PS=12.4U PD=6.4U
* device instance $7 r0 *1 22.1,6.8 NMOS
M$7 \$5 B GND GND NMOS L=1U W=3.4U AS=5.1P AD=5.1P PS=6.4U PD=6.4U
* device instance $8 r0 *1 26.1,6.8 NMOS
M$8 Y A \$5 GND NMOS L=1U W=3.4U AS=5.1P AD=9.52P PS=6.4U PD=12.4U
* device instance $9 r0 *1 6.1,6.8 NMOS
M$9 GND A \$2 GND NMOS L=1U W=3.4U AS=9.52P AD=5.1P PS=12.4U PD=6.4U
* device instance $10 r0 *1 10.1,6.8 NMOS
M$10 \$2 B GND GND NMOS L=1U W=3.4U AS=5.1P AD=9.52P PS=6.4U PD=12.4U
.ENDS XOR2

* ==== TIEHI ====
.SUBCKT TIEHI HI VDD GND
.ENDS TIEHI

* ==== TIELO ====
.SUBCKT TIELO LO VDD GND
.ENDS TIELO

.SUBCKT ANTENNAN_X1 ANT GND
MANT ANT GND GND GND NMOS L=1u W=3.4u AS=9.52p AD=9.52p PS=12.4u PD=12.4u
.ENDS ANTENNAN_X1
